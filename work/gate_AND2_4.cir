* gate_AND2
.include C:/Users/udhav/DVD-Project/models/16nm_HP.pm
.options gmin=1e-18 abstol=1e-18 reltol=1e-6 vntol=1e-9
Vdd vdd 0 0
Va a 0 0
Vb b 0 0
Mnand20_MP_A g_nd a vdd vdd pmos W=6.400000000e-08 L=1.600000000e-08
Mnand20_MP_B g_nd b vdd vdd pmos W=6.400000000e-08 L=1.600000000e-08
Mnand20_MN_A g_nd a nand20_x 0 nmos W=3.200000000e-08 L=1.600000000e-08
Mnand20_MN_B nand20_x b 0 0 nmos W=3.200000000e-08 L=1.600000000e-08
Minv1_MP out g_nd vdd vdd pmos W=6.400000000e-08 L=1.600000000e-08
Minv1_MN out g_nd 0 0 nmos W=3.200000000e-08 L=1.600000000e-08
.control
set appendwrite
set wr_vecnames=0
altermod nmos vth0=4.745934169e-01
altermod nmos toxe=9.068670929e-10
altermod nmos ndep=6.406241942e+18
altermod nmos u0=3.083776448e-02
altermod nmos xj=4.959953667e-09
altermod pmos vth0=-4.443309211e-01
altermod pmos toxe=1.095406007e-09
altermod pmos ndep=5.541843602e+18
altermod pmos u0=6.127861076e-03
altermod pmos xj=5.186913911e-09
alter vdd dc=1.093565610e+00
alter va dc=0.000000000e+00
alter vb dc=1.093565610e+00
option temp=10.557746
op
let idx = 0
wrdata C:/Users/udhav/DVD-Project/work/gate_AND2_4.out idx i(Vdd) i(Va) i(Vb) v(g_nd) v(nand20_x) v(out)
destroy all
altermod nmos vth0=5.000726278e-01
altermod nmos toxe=9.637271752e-10
altermod nmos ndep=6.583473696e+18
altermod nmos u0=3.131303687e-02
altermod nmos xj=5.022636675e-09
altermod pmos vth0=-4.278594152e-01
altermod pmos toxe=9.587440958e-10
altermod pmos ndep=5.004631822e+18
altermod pmos u0=5.637311831e-03
altermod pmos xj=5.203328156e-09
alter vdd dc=9.430008075e-01
alter va dc=0.000000000e+00
alter vb dc=9.430008075e-01
option temp=97.411061
op
let idx = 1
wrdata C:/Users/udhav/DVD-Project/work/gate_AND2_4.out idx i(Vdd) i(Va) i(Vb) v(g_nd) v(nand20_x) v(out)
destroy all
altermod nmos vth0=4.349840039e-01
altermod nmos toxe=9.512778763e-10
altermod nmos ndep=6.766580683e+18
altermod nmos u0=3.009804012e-02
altermod nmos xj=5.114426230e-09
altermod pmos vth0=-3.890959561e-01
altermod pmos toxe=1.007499304e-09
altermod pmos ndep=5.854717894e+18
altermod pmos u0=6.238193746e-03
altermod pmos xj=5.491188326e-09
alter vdd dc=1.034353033e+00
alter va dc=0.000000000e+00
alter vb dc=1.034353033e+00
option temp=62.287371
op
let idx = 2
wrdata C:/Users/udhav/DVD-Project/work/gate_AND2_4.out idx i(Vdd) i(Va) i(Vb) v(g_nd) v(nand20_x) v(out)
destroy all
altermod nmos vth0=4.690783609e-01
altermod nmos toxe=8.692706224e-10
altermod nmos ndep=6.398659762e+18
altermod nmos u0=3.223919045e-02
altermod nmos xj=5.489536824e-09
altermod pmos vth0=-4.497676686e-01
altermod pmos toxe=9.716399537e-10
altermod pmos ndep=5.713442157e+18
altermod pmos u0=5.539125429e-03
altermod pmos xj=4.523420655e-09
alter vdd dc=9.600840163e-01
alter va dc=0.000000000e+00
alter vb dc=9.600840163e-01
option temp=-9.121341
op
let idx = 3
wrdata C:/Users/udhav/DVD-Project/work/gate_AND2_4.out idx i(Vdd) i(Va) i(Vb) v(g_nd) v(nand20_x) v(out)
destroy all
altermod nmos vth0=5.142168105e-01
altermod nmos toxe=8.787261327e-10
altermod nmos ndep=6.343203776e+18
altermod nmos u0=2.981181588e-02
altermod nmos xj=5.187402109e-09
altermod pmos vth0=-4.102255352e-01
altermod pmos toxe=9.106813463e-10
altermod pmos ndep=5.951155590e+18
altermod pmos u0=5.723774775e-03
altermod pmos xj=5.164818225e-09
alter vdd dc=1.074815405e+00
alter va dc=0.000000000e+00
alter vb dc=1.074815405e+00
option temp=31.744213
op
let idx = 4
wrdata C:/Users/udhav/DVD-Project/work/gate_AND2_4.out idx i(Vdd) i(Va) i(Vb) v(g_nd) v(nand20_x) v(out)
destroy all
altermod nmos vth0=4.872802106e-01
altermod nmos toxe=1.023108097e-09
altermod nmos ndep=7.597688629e+18
altermod nmos u0=2.978935649e-02
altermod nmos xj=4.892387419e-09
altermod pmos vth0=-4.554058822e-01
altermod pmos toxe=1.080176790e-09
altermod pmos ndep=5.247150800e+18
altermod pmos u0=5.937764494e-03
altermod pmos xj=5.244957554e-09
alter vdd dc=1.032442948e+00
alter va dc=0.000000000e+00
alter vb dc=1.032442948e+00
option temp=105.847207
op
let idx = 5
wrdata C:/Users/udhav/DVD-Project/work/gate_AND2_4.out idx i(Vdd) i(Va) i(Vb) v(g_nd) v(nand20_x) v(out)
destroy all
altermod nmos vth0=4.851972315e-01
altermod nmos toxe=9.450888872e-10
altermod nmos ndep=6.909292081e+18
altermod nmos u0=2.870807778e-02
altermod nmos xj=5.215020793e-09
altermod pmos vth0=-4.302273391e-01
altermod pmos toxe=1.087131484e-09
altermod pmos ndep=5.813688463e+18
altermod pmos u0=5.537329221e-03
altermod pmos xj=5.248173949e-09
alter vdd dc=9.263231632e-01
alter va dc=0.000000000e+00
alter vb dc=9.263231632e-01
option temp=21.936713
op
let idx = 6
wrdata C:/Users/udhav/DVD-Project/work/gate_AND2_4.out idx i(Vdd) i(Va) i(Vb) v(g_nd) v(nand20_x) v(out)
destroy all
altermod nmos vth0=4.954534013e-01
altermod nmos toxe=1.007875883e-09
altermod nmos ndep=6.586838245e+18
altermod nmos u0=3.251622980e-02
altermod nmos xj=4.966731287e-09
altermod pmos vth0=-4.342785776e-01
altermod pmos toxe=9.372865434e-10
altermod pmos ndep=5.910429391e+18
altermod pmos u0=5.527188780e-03
altermod pmos xj=5.214021462e-09
alter vdd dc=1.069014864e+00
alter va dc=0.000000000e+00
alter vb dc=1.069014864e+00
option temp=77.295456
op
let idx = 7
wrdata C:/Users/udhav/DVD-Project/work/gate_AND2_4.out idx i(Vdd) i(Va) i(Vb) v(g_nd) v(nand20_x) v(out)
destroy all
altermod nmos vth0=4.966940397e-01
altermod nmos toxe=8.676503415e-10
altermod nmos ndep=7.291832522e+18
altermod nmos u0=2.889761880e-02
altermod nmos xj=4.913119989e-09
altermod pmos vth0=-4.275186618e-01
altermod pmos toxe=9.835993914e-10
altermod pmos ndep=5.340556212e+18
altermod pmos u0=6.182724005e-03
altermod pmos xj=4.572212489e-09
alter vdd dc=1.088989634e+00
alter va dc=0.000000000e+00
alter vb dc=1.088989634e+00
option temp=-24.026728
op
let idx = 8
wrdata C:/Users/udhav/DVD-Project/work/gate_AND2_4.out idx i(Vdd) i(Va) i(Vb) v(g_nd) v(nand20_x) v(out)
destroy all
altermod nmos vth0=4.876695802e-01
altermod nmos toxe=9.680144960e-10
altermod nmos ndep=6.313223478e+18
altermod nmos u0=3.117162764e-02
altermod nmos xj=4.865653217e-09
altermod pmos vth0=-4.463870320e-01
altermod pmos toxe=9.747281494e-10
altermod pmos ndep=5.401206811e+18
altermod pmos u0=6.290348990e-03
altermod pmos xj=4.583938456e-09
alter vdd dc=1.080783358e+00
alter va dc=0.000000000e+00
alter vb dc=1.080783358e+00
option temp=80.008588
op
let idx = 9
wrdata C:/Users/udhav/DVD-Project/work/gate_AND2_4.out idx i(Vdd) i(Va) i(Vb) v(g_nd) v(nand20_x) v(out)
destroy all
altermod nmos vth0=4.720359698e-01
altermod nmos toxe=1.019409271e-09
altermod nmos ndep=6.643024147e+18
altermod nmos u0=2.945611762e-02
altermod nmos xj=4.993406095e-09
altermod pmos vth0=-4.734724758e-01
altermod pmos toxe=9.334433985e-10
altermod pmos ndep=5.317386215e+18
altermod pmos u0=5.844829020e-03
altermod pmos xj=5.272801993e-09
alter vdd dc=1.013943830e+00
alter va dc=0.000000000e+00
alter vb dc=1.013943830e+00
option temp=88.118131
op
let idx = 10
wrdata C:/Users/udhav/DVD-Project/work/gate_AND2_4.out idx i(Vdd) i(Va) i(Vb) v(g_nd) v(nand20_x) v(out)
destroy all
altermod nmos vth0=4.492865902e-01
altermod nmos toxe=1.019742558e-09
altermod nmos ndep=7.645049495e+18
altermod nmos u0=3.261254479e-02
altermod nmos xj=4.781182159e-09
altermod pmos vth0=-4.568991312e-01
altermod pmos toxe=1.032332127e-09
altermod pmos ndep=4.956300303e+18
altermod pmos u0=5.867825303e-03
altermod pmos xj=5.111770449e-09
alter vdd dc=9.290919908e-01
alter va dc=0.000000000e+00
alter vb dc=9.290919908e-01
option temp=96.251519
op
let idx = 11
wrdata C:/Users/udhav/DVD-Project/work/gate_AND2_4.out idx i(Vdd) i(Va) i(Vb) v(g_nd) v(nand20_x) v(out)
destroy all
altermod nmos vth0=4.597581504e-01
altermod nmos toxe=8.560872616e-10
altermod nmos ndep=7.556766242e+18
altermod nmos u0=3.268775620e-02
altermod nmos xj=4.742100342e-09
altermod pmos vth0=-3.940484824e-01
altermod pmos toxe=1.056399212e-09
altermod pmos ndep=5.204713134e+18
altermod pmos u0=5.649121201e-03
altermod pmos xj=4.762674110e-09
alter vdd dc=9.384926990e-01
alter va dc=0.000000000e+00
alter vb dc=9.384926990e-01
option temp=71.243163
op
let idx = 12
wrdata C:/Users/udhav/DVD-Project/work/gate_AND2_4.out idx i(Vdd) i(Va) i(Vb) v(g_nd) v(nand20_x) v(out)
destroy all
altermod nmos vth0=4.597850244e-01
altermod nmos toxe=9.541268199e-10
altermod nmos ndep=7.190295351e+18
altermod nmos u0=2.718021140e-02
altermod nmos xj=4.648466656e-09
altermod pmos vth0=-4.307617326e-01
altermod pmos toxe=1.051939604e-09
altermod pmos ndep=5.314689979e+18
altermod pmos u0=6.025953364e-03
altermod pmos xj=4.509290394e-09
alter vdd dc=1.085581137e+00
alter va dc=0.000000000e+00
alter vb dc=1.085581137e+00
option temp=21.170911
op
let idx = 13
wrdata C:/Users/udhav/DVD-Project/work/gate_AND2_4.out idx i(Vdd) i(Va) i(Vb) v(g_nd) v(nand20_x) v(out)
destroy all
altermod nmos vth0=4.730063606e-01
altermod nmos toxe=9.251109024e-10
altermod nmos ndep=6.430483880e+18
altermod nmos u0=3.296720164e-02
altermod nmos xj=4.940224621e-09
altermod pmos vth0=-4.082944333e-01
altermod pmos toxe=1.035050391e-09
altermod pmos ndep=5.069244185e+18
altermod pmos u0=6.096442202e-03
altermod pmos xj=5.033457988e-09
alter vdd dc=1.010465298e+00
alter va dc=0.000000000e+00
alter vb dc=1.010465298e+00
option temp=-29.405020
op
let idx = 14
wrdata C:/Users/udhav/DVD-Project/work/gate_AND2_4.out idx i(Vdd) i(Va) i(Vb) v(g_nd) v(nand20_x) v(out)
destroy all
altermod nmos vth0=5.275247064e-01
altermod nmos toxe=9.994079855e-10
altermod nmos ndep=6.745271183e+18
altermod nmos u0=3.062961657e-02
altermod nmos xj=4.793261312e-09
altermod pmos vth0=-3.969200898e-01
altermod pmos toxe=9.034980818e-10
altermod pmos ndep=5.792111871e+18
altermod pmos u0=6.520327815e-03
altermod pmos xj=4.590423772e-09
alter vdd dc=9.361104997e-01
alter va dc=0.000000000e+00
alter vb dc=9.361104997e-01
option temp=45.598079
op
let idx = 15
wrdata C:/Users/udhav/DVD-Project/work/gate_AND2_4.out idx i(Vdd) i(Va) i(Vb) v(g_nd) v(nand20_x) v(out)
destroy all
altermod nmos vth0=4.655053078e-01
altermod nmos toxe=8.689116094e-10
altermod nmos ndep=6.339105570e+18
altermod nmos u0=2.744312084e-02
altermod nmos xj=5.336941519e-09
altermod pmos vth0=-4.049213289e-01
altermod pmos toxe=9.459194826e-10
altermod pmos ndep=5.419647879e+18
altermod pmos u0=5.448696057e-03
altermod pmos xj=5.248381767e-09
alter vdd dc=1.076811379e+00
alter va dc=0.000000000e+00
alter vb dc=1.076811379e+00
option temp=84.980885
op
let idx = 16
wrdata C:/Users/udhav/DVD-Project/work/gate_AND2_4.out idx i(Vdd) i(Va) i(Vb) v(g_nd) v(nand20_x) v(out)
destroy all
altermod nmos vth0=4.746020945e-01
altermod nmos toxe=9.053360468e-10
altermod nmos ndep=6.606867406e+18
altermod nmos u0=2.998218491e-02
altermod nmos xj=5.347894154e-09
altermod pmos vth0=-4.094868758e-01
altermod pmos toxe=1.002920227e-09
altermod pmos ndep=5.575035714e+18
altermod pmos u0=6.490469992e-03
altermod pmos xj=4.840721915e-09
alter vdd dc=1.028314341e+00
alter va dc=0.000000000e+00
alter vb dc=1.028314341e+00
option temp=-8.511696
op
let idx = 17
wrdata C:/Users/udhav/DVD-Project/work/gate_AND2_4.out idx i(Vdd) i(Va) i(Vb) v(g_nd) v(nand20_x) v(out)
destroy all
altermod nmos vth0=4.673352322e-01
altermod nmos toxe=1.009402129e-09
altermod nmos ndep=6.335607773e+18
altermod nmos u0=2.729683164e-02
altermod nmos xj=4.843876672e-09
altermod pmos vth0=-4.708578598e-01
altermod pmos toxe=1.040568119e-09
altermod pmos ndep=5.263067278e+18
altermod pmos u0=6.588777205e-03
altermod pmos xj=5.307478591e-09
alter vdd dc=1.013938855e+00
alter va dc=0.000000000e+00
alter vb dc=1.013938855e+00
option temp=3.929142
op
let idx = 18
wrdata C:/Users/udhav/DVD-Project/work/gate_AND2_4.out idx i(Vdd) i(Va) i(Vb) v(g_nd) v(nand20_x) v(out)
destroy all
altermod nmos vth0=4.874613631e-01
altermod nmos toxe=9.442156823e-10
altermod nmos ndep=6.476629151e+18
altermod nmos u0=3.029336290e-02
altermod nmos xj=5.119142085e-09
altermod pmos vth0=-4.523276212e-01
altermod pmos toxe=9.772847254e-10
altermod pmos ndep=5.346383137e+18
altermod pmos u0=5.815540816e-03
altermod pmos xj=4.595555745e-09
alter vdd dc=9.752575672e-01
alter va dc=0.000000000e+00
alter vb dc=9.752575672e-01
option temp=48.459807
op
let idx = 19
wrdata C:/Users/udhav/DVD-Project/work/gate_AND2_4.out idx i(Vdd) i(Va) i(Vb) v(g_nd) v(nand20_x) v(out)
destroy all
altermod nmos vth0=5.226169107e-01
altermod nmos toxe=9.410985611e-10
altermod nmos ndep=7.186500358e+18
altermod nmos u0=2.811272693e-02
altermod nmos xj=5.402290832e-09
altermod pmos vth0=-4.616507728e-01
altermod pmos toxe=9.898533619e-10
altermod pmos ndep=5.778722454e+18
altermod pmos u0=6.270969537e-03
altermod pmos xj=4.993976077e-09
alter vdd dc=9.821910564e-01
alter va dc=0.000000000e+00
alter vb dc=9.821910564e-01
option temp=83.474708
op
let idx = 20
wrdata C:/Users/udhav/DVD-Project/work/gate_AND2_4.out idx i(Vdd) i(Va) i(Vb) v(g_nd) v(nand20_x) v(out)
destroy all
altermod nmos vth0=5.169737627e-01
altermod nmos toxe=1.039026143e-09
altermod nmos ndep=6.440619982e+18
altermod nmos u0=2.920764203e-02
altermod nmos xj=4.859161927e-09
altermod pmos vth0=-4.483568371e-01
altermod pmos toxe=1.068143829e-09
altermod pmos ndep=5.466799766e+18
altermod pmos u0=6.389813577e-03
altermod pmos xj=4.599764980e-09
alter vdd dc=9.478978425e-01
alter va dc=0.000000000e+00
alter vb dc=9.478978425e-01
option temp=107.936811
op
let idx = 21
wrdata C:/Users/udhav/DVD-Project/work/gate_AND2_4.out idx i(Vdd) i(Va) i(Vb) v(g_nd) v(nand20_x) v(out)
destroy all
altermod nmos vth0=4.678639199e-01
altermod nmos toxe=9.157792258e-10
altermod nmos ndep=6.518068306e+18
altermod nmos u0=2.882820070e-02
altermod nmos xj=5.054715729e-09
altermod pmos vth0=-4.153116431e-01
altermod pmos toxe=9.047093952e-10
altermod pmos ndep=5.606174224e+18
altermod pmos u0=6.181351837e-03
altermod pmos xj=5.280360125e-09
alter vdd dc=9.076114573e-01
alter va dc=0.000000000e+00
alter vb dc=9.076114573e-01
option temp=-19.252650
op
let idx = 22
wrdata C:/Users/udhav/DVD-Project/work/gate_AND2_4.out idx i(Vdd) i(Va) i(Vb) v(g_nd) v(nand20_x) v(out)
destroy all
altermod nmos vth0=4.572888266e-01
altermod nmos toxe=8.629271911e-10
altermod nmos ndep=7.563931176e+18
altermod nmos u0=3.061327209e-02
altermod nmos xj=4.943558619e-09
altermod pmos vth0=-4.218187200e-01
altermod pmos toxe=9.537177866e-10
altermod pmos ndep=5.414948567e+18
altermod pmos u0=5.746685510e-03
altermod pmos xj=5.059983102e-09
alter vdd dc=1.075243762e+00
alter va dc=0.000000000e+00
alter vb dc=1.075243762e+00
option temp=-9.595415
op
let idx = 23
wrdata C:/Users/udhav/DVD-Project/work/gate_AND2_4.out idx i(Vdd) i(Va) i(Vb) v(g_nd) v(nand20_x) v(out)
destroy all
altermod nmos vth0=5.165253581e-01
altermod nmos toxe=9.295181585e-10
altermod nmos ndep=6.769633393e+18
altermod nmos u0=3.193417189e-02
altermod nmos xj=5.150265228e-09
altermod pmos vth0=-4.260942534e-01
altermod pmos toxe=9.579870317e-10
altermod pmos ndep=5.562738360e+18
altermod pmos u0=6.147487926e-03
altermod pmos xj=4.734687572e-09
alter vdd dc=9.935460434e-01
alter va dc=0.000000000e+00
alter vb dc=9.935460434e-01
option temp=91.923600
op
let idx = 24
wrdata C:/Users/udhav/DVD-Project/work/gate_AND2_4.out idx i(Vdd) i(Va) i(Vb) v(g_nd) v(nand20_x) v(out)
destroy all
altermod nmos vth0=4.790584322e-01
altermod nmos toxe=8.841409767e-10
altermod nmos ndep=6.766195694e+18
altermod nmos u0=3.261921976e-02
altermod nmos xj=5.459770873e-09
altermod pmos vth0=-4.133930421e-01
altermod pmos toxe=1.098556524e-09
altermod pmos ndep=5.937094112e+18
altermod pmos u0=6.452290548e-03
altermod pmos xj=5.462853027e-09
alter vdd dc=1.009527040e+00
alter va dc=0.000000000e+00
alter vb dc=1.009527040e+00
option temp=66.346068
op
let idx = 25
wrdata C:/Users/udhav/DVD-Project/work/gate_AND2_4.out idx i(Vdd) i(Va) i(Vb) v(g_nd) v(nand20_x) v(out)
destroy all
altermod nmos vth0=4.974489622e-01
altermod nmos toxe=8.705594527e-10
altermod nmos ndep=6.421155259e+18
altermod nmos u0=2.897314850e-02
altermod nmos xj=4.638623687e-09
altermod pmos vth0=-4.244350473e-01
altermod pmos toxe=9.455072220e-10
altermod pmos ndep=5.244141881e+18
altermod pmos u0=5.528456980e-03
altermod pmos xj=5.181994962e-09
alter vdd dc=9.644326620e-01
alter va dc=0.000000000e+00
alter vb dc=9.644326620e-01
option temp=78.960511
op
let idx = 26
wrdata C:/Users/udhav/DVD-Project/work/gate_AND2_4.out idx i(Vdd) i(Va) i(Vb) v(g_nd) v(nand20_x) v(out)
destroy all
altermod nmos vth0=4.387158462e-01
altermod nmos toxe=9.628934678e-10
altermod nmos ndep=7.414302731e+18
altermod nmos u0=3.041813967e-02
altermod nmos xj=5.465385329e-09
altermod pmos vth0=-4.545976926e-01
altermod pmos toxe=9.094226326e-10
altermod pmos ndep=5.520968160e+18
altermod pmos u0=5.975967945e-03
altermod pmos xj=4.836342082e-09
alter vdd dc=1.050264984e+00
alter va dc=0.000000000e+00
alter vb dc=1.050264984e+00
option temp=124.467242
op
let idx = 27
wrdata C:/Users/udhav/DVD-Project/work/gate_AND2_4.out idx i(Vdd) i(Va) i(Vb) v(g_nd) v(nand20_x) v(out)
destroy all
altermod nmos vth0=5.148138799e-01
altermod nmos toxe=1.036179367e-09
altermod nmos ndep=7.246928137e+18
altermod nmos u0=2.703539502e-02
altermod nmos xj=5.165733516e-09
altermod pmos vth0=-3.946178149e-01
altermod pmos toxe=9.832928413e-10
altermod pmos ndep=5.705948718e+18
altermod pmos u0=5.427174487e-03
altermod pmos xj=5.355332405e-09
alter vdd dc=9.050393742e-01
alter va dc=0.000000000e+00
alter vb dc=9.050393742e-01
option temp=114.964693
op
let idx = 28
wrdata C:/Users/udhav/DVD-Project/work/gate_AND2_4.out idx i(Vdd) i(Va) i(Vb) v(g_nd) v(nand20_x) v(out)
destroy all
altermod nmos vth0=4.617077480e-01
altermod nmos toxe=9.650874391e-10
altermod nmos ndep=7.065985921e+18
altermod nmos u0=2.923298119e-02
altermod nmos xj=5.295870512e-09
altermod pmos vth0=-4.119413657e-01
altermod pmos toxe=1.029905773e-09
altermod pmos ndep=5.045468438e+18
altermod pmos u0=6.413952219e-03
altermod pmos xj=4.879982299e-09
alter vdd dc=9.744370545e-01
alter va dc=0.000000000e+00
alter vb dc=9.744370545e-01
option temp=99.099136
op
let idx = 29
wrdata C:/Users/udhav/DVD-Project/work/gate_AND2_4.out idx i(Vdd) i(Va) i(Vb) v(g_nd) v(nand20_x) v(out)
destroy all
altermod nmos vth0=4.791249710e-01
altermod nmos toxe=9.779517640e-10
altermod nmos ndep=7.165077979e+18
altermod nmos u0=3.276422294e-02
altermod nmos xj=5.135121811e-09
altermod pmos vth0=-4.294011623e-01
altermod pmos toxe=9.306834705e-10
altermod pmos ndep=6.008208345e+18
altermod pmos u0=6.334188091e-03
altermod pmos xj=5.442464999e-09
alter vdd dc=9.060700589e-01
alter va dc=0.000000000e+00
alter vb dc=9.060700589e-01
option temp=88.224108
op
let idx = 30
wrdata C:/Users/udhav/DVD-Project/work/gate_AND2_4.out idx i(Vdd) i(Va) i(Vb) v(g_nd) v(nand20_x) v(out)
destroy all
altermod nmos vth0=4.506811624e-01
altermod nmos toxe=9.164894837e-10
altermod nmos ndep=6.440532969e+18
altermod nmos u0=2.771303131e-02
altermod nmos xj=5.370316996e-09
altermod pmos vth0=-4.464079722e-01
altermod pmos toxe=1.067938964e-09
altermod pmos ndep=5.498633514e+18
altermod pmos u0=5.455240492e-03
altermod pmos xj=4.797115761e-09
alter vdd dc=9.245784204e-01
alter va dc=0.000000000e+00
alter vb dc=9.245784204e-01
option temp=25.178171
op
let idx = 31
wrdata C:/Users/udhav/DVD-Project/work/gate_AND2_4.out idx i(Vdd) i(Va) i(Vb) v(g_nd) v(nand20_x) v(out)
destroy all
altermod nmos vth0=4.719988748e-01
altermod nmos toxe=9.635133428e-10
altermod nmos ndep=6.664428494e+18
altermod nmos u0=3.221896665e-02
altermod nmos xj=4.826238736e-09
altermod pmos vth0=-4.437951585e-01
altermod pmos toxe=9.392912597e-10
altermod pmos ndep=5.219870942e+18
altermod pmos u0=6.294973560e-03
altermod pmos xj=5.484361186e-09
alter vdd dc=1.093429647e+00
alter va dc=0.000000000e+00
alter vb dc=1.093429647e+00
option temp=65.802803
op
let idx = 32
wrdata C:/Users/udhav/DVD-Project/work/gate_AND2_4.out idx i(Vdd) i(Va) i(Vb) v(g_nd) v(nand20_x) v(out)
destroy all
altermod nmos vth0=5.111197326e-01
altermod nmos toxe=9.979264576e-10
altermod nmos ndep=7.117098122e+18
altermod nmos u0=3.091503118e-02
altermod nmos xj=5.208047651e-09
altermod pmos vth0=-4.506132054e-01
altermod pmos toxe=1.040855854e-09
altermod pmos ndep=5.786473861e+18
altermod pmos u0=6.229868462e-03
altermod pmos xj=4.562483047e-09
alter vdd dc=1.031552146e+00
alter va dc=0.000000000e+00
alter vb dc=1.031552146e+00
option temp=-9.566469
op
let idx = 33
wrdata C:/Users/udhav/DVD-Project/work/gate_AND2_4.out idx i(Vdd) i(Va) i(Vb) v(g_nd) v(nand20_x) v(out)
destroy all
altermod nmos vth0=5.110746772e-01
altermod nmos toxe=9.669641225e-10
altermod nmos ndep=7.633124714e+18
altermod nmos u0=2.876336237e-02
altermod nmos xj=4.764113032e-09
altermod pmos vth0=-3.971670143e-01
altermod pmos toxe=9.323616013e-10
altermod pmos ndep=5.847138995e+18
altermod pmos u0=5.551501522e-03
altermod pmos xj=5.234570798e-09
alter vdd dc=9.856440493e-01
alter va dc=0.000000000e+00
alter vb dc=9.856440493e-01
option temp=85.316587
op
let idx = 34
wrdata C:/Users/udhav/DVD-Project/work/gate_AND2_4.out idx i(Vdd) i(Va) i(Vb) v(g_nd) v(nand20_x) v(out)
destroy all
altermod nmos vth0=4.771243562e-01
altermod nmos toxe=1.007527891e-09
altermod nmos ndep=7.443984719e+18
altermod nmos u0=3.166896568e-02
altermod nmos xj=5.008657235e-09
altermod pmos vth0=-4.036774909e-01
altermod pmos toxe=1.076345033e-09
altermod pmos ndep=5.643681701e+18
altermod pmos u0=6.030202098e-03
altermod pmos xj=4.791400933e-09
alter vdd dc=1.004748022e+00
alter va dc=0.000000000e+00
alter vb dc=1.004748022e+00
option temp=85.018960
op
let idx = 35
wrdata C:/Users/udhav/DVD-Project/work/gate_AND2_4.out idx i(Vdd) i(Va) i(Vb) v(g_nd) v(nand20_x) v(out)
destroy all
altermod nmos vth0=5.053506736e-01
altermod nmos toxe=9.595894293e-10
altermod nmos ndep=7.197016902e+18
altermod nmos u0=2.873568821e-02
altermod nmos xj=5.181490462e-09
altermod pmos vth0=-4.147360744e-01
altermod pmos toxe=9.402640885e-10
altermod pmos ndep=5.957779050e+18
altermod pmos u0=6.227231764e-03
altermod pmos xj=4.923902146e-09
alter vdd dc=1.074561842e+00
alter va dc=0.000000000e+00
alter vb dc=1.074561842e+00
option temp=79.013710
op
let idx = 36
wrdata C:/Users/udhav/DVD-Project/work/gate_AND2_4.out idx i(Vdd) i(Va) i(Vb) v(g_nd) v(nand20_x) v(out)
destroy all
altermod nmos vth0=4.756273544e-01
altermod nmos toxe=8.926473707e-10
altermod nmos ndep=7.026346010e+18
altermod nmos u0=3.236889035e-02
altermod nmos xj=4.701124292e-09
altermod pmos vth0=-4.123823111e-01
altermod pmos toxe=1.046271777e-09
altermod pmos ndep=5.047801763e+18
altermod pmos u0=5.802582572e-03
altermod pmos xj=5.136185448e-09
alter vdd dc=9.688421334e-01
alter va dc=0.000000000e+00
alter vb dc=9.688421334e-01
option temp=33.391839
op
let idx = 37
wrdata C:/Users/udhav/DVD-Project/work/gate_AND2_4.out idx i(Vdd) i(Va) i(Vb) v(g_nd) v(nand20_x) v(out)
destroy all
altermod nmos vth0=4.675010737e-01
altermod nmos toxe=9.657179883e-10
altermod nmos ndep=6.321185047e+18
altermod nmos u0=2.749655494e-02
altermod nmos xj=4.561159416e-09
altermod pmos vth0=-4.532526784e-01
altermod pmos toxe=1.067738807e-09
altermod pmos ndep=5.530358338e+18
altermod pmos u0=6.004677959e-03
altermod pmos xj=4.545830085e-09
alter vdd dc=1.018058196e+00
alter va dc=0.000000000e+00
alter vb dc=1.018058196e+00
option temp=22.399754
op
let idx = 38
wrdata C:/Users/udhav/DVD-Project/work/gate_AND2_4.out idx i(Vdd) i(Va) i(Vb) v(g_nd) v(nand20_x) v(out)
destroy all
altermod nmos vth0=4.840521295e-01
altermod nmos toxe=9.482778110e-10
altermod nmos ndep=7.547002775e+18
altermod nmos u0=2.771395833e-02
altermod nmos xj=5.290948112e-09
altermod pmos vth0=-4.737547134e-01
altermod pmos toxe=9.509892828e-10
altermod pmos ndep=5.767179093e+18
altermod pmos u0=6.571118704e-03
altermod pmos xj=4.723539588e-09
alter vdd dc=1.036736875e+00
alter va dc=0.000000000e+00
alter vb dc=1.036736875e+00
option temp=29.262204
op
let idx = 39
wrdata C:/Users/udhav/DVD-Project/work/gate_AND2_4.out idx i(Vdd) i(Va) i(Vb) v(g_nd) v(nand20_x) v(out)
destroy all
altermod nmos vth0=4.509996198e-01
altermod nmos toxe=8.865277512e-10
altermod nmos ndep=6.393595734e+18
altermod nmos u0=3.150007309e-02
altermod nmos xj=5.308946293e-09
altermod pmos vth0=-4.470021729e-01
altermod pmos toxe=9.185652110e-10
altermod pmos ndep=5.958499947e+18
altermod pmos u0=6.162818215e-03
altermod pmos xj=4.604016848e-09
alter vdd dc=9.710827554e-01
alter va dc=0.000000000e+00
alter vb dc=9.710827554e-01
option temp=-34.499026
op
let idx = 40
wrdata C:/Users/udhav/DVD-Project/work/gate_AND2_4.out idx i(Vdd) i(Va) i(Vb) v(g_nd) v(nand20_x) v(out)
destroy all
altermod nmos vth0=4.620527471e-01
altermod nmos toxe=9.726415117e-10
altermod nmos ndep=6.480713471e+18
altermod nmos u0=2.969506982e-02
altermod nmos xj=5.165664860e-09
altermod pmos vth0=-3.909389923e-01
altermod pmos toxe=1.017228252e-09
altermod pmos ndep=5.655591460e+18
altermod pmos u0=6.002391983e-03
altermod pmos xj=5.239645570e-09
alter vdd dc=1.003819697e+00
alter va dc=0.000000000e+00
alter vb dc=1.003819697e+00
option temp=99.312819
op
let idx = 41
wrdata C:/Users/udhav/DVD-Project/work/gate_AND2_4.out idx i(Vdd) i(Va) i(Vb) v(g_nd) v(nand20_x) v(out)
destroy all
altermod nmos vth0=4.994623050e-01
altermod nmos toxe=1.010222503e-09
altermod nmos ndep=7.270300434e+18
altermod nmos u0=2.788478004e-02
altermod nmos xj=4.821431616e-09
altermod pmos vth0=-4.137541347e-01
altermod pmos toxe=9.998042045e-10
altermod pmos ndep=5.612543023e+18
altermod pmos u0=5.479196930e-03
altermod pmos xj=4.721241652e-09
alter vdd dc=1.053049477e+00
alter va dc=0.000000000e+00
alter vb dc=1.053049477e+00
option temp=49.491030
op
let idx = 42
wrdata C:/Users/udhav/DVD-Project/work/gate_AND2_4.out idx i(Vdd) i(Va) i(Vb) v(g_nd) v(nand20_x) v(out)
destroy all
altermod nmos vth0=5.056004062e-01
altermod nmos toxe=8.806666618e-10
altermod nmos ndep=7.437001573e+18
altermod nmos u0=3.008060427e-02
altermod nmos xj=5.158173006e-09
altermod pmos vth0=-4.573436761e-01
altermod pmos toxe=9.958639324e-10
altermod pmos ndep=5.377050814e+18
altermod pmos u0=5.545405727e-03
altermod pmos xj=4.998332385e-09
alter vdd dc=1.081835863e+00
alter va dc=0.000000000e+00
alter vb dc=1.081835863e+00
option temp=23.940575
op
let idx = 43
wrdata C:/Users/udhav/DVD-Project/work/gate_AND2_4.out idx i(Vdd) i(Va) i(Vb) v(g_nd) v(nand20_x) v(out)
destroy all
altermod nmos vth0=4.371250114e-01
altermod nmos toxe=9.585397137e-10
altermod nmos ndep=7.401170929e+18
altermod nmos u0=2.878181474e-02
altermod nmos xj=4.583880385e-09
altermod pmos vth0=-4.678059369e-01
altermod pmos toxe=1.056266880e-09
altermod pmos ndep=5.578771035e+18
altermod pmos u0=6.420924073e-03
altermod pmos xj=4.828513411e-09
alter vdd dc=9.302124556e-01
alter va dc=0.000000000e+00
alter vb dc=9.302124556e-01
option temp=50.424747
op
let idx = 44
wrdata C:/Users/udhav/DVD-Project/work/gate_AND2_4.out idx i(Vdd) i(Va) i(Vb) v(g_nd) v(nand20_x) v(out)
destroy all
altermod nmos vth0=5.019850116e-01
altermod nmos toxe=9.944005552e-10
altermod nmos ndep=6.933365768e+18
altermod nmos u0=3.029589170e-02
altermod nmos xj=5.162509629e-09
altermod pmos vth0=-4.393954189e-01
altermod pmos toxe=9.926219295e-10
altermod pmos ndep=5.560276587e+18
altermod pmos u0=6.291118302e-03
altermod pmos xj=4.736116774e-09
alter vdd dc=1.086683878e+00
alter va dc=0.000000000e+00
alter vb dc=1.086683878e+00
option temp=79.070636
op
let idx = 45
wrdata C:/Users/udhav/DVD-Project/work/gate_AND2_4.out idx i(Vdd) i(Va) i(Vb) v(g_nd) v(nand20_x) v(out)
destroy all
altermod nmos vth0=5.101010537e-01
altermod nmos toxe=9.315733433e-10
altermod nmos ndep=6.547878089e+18
altermod nmos u0=3.146228354e-02
altermod nmos xj=5.076198550e-09
altermod pmos vth0=-4.181721538e-01
altermod pmos toxe=9.994062811e-10
altermod pmos ndep=5.945527487e+18
altermod pmos u0=6.402113815e-03
altermod pmos xj=5.435177799e-09
alter vdd dc=9.010357732e-01
alter va dc=0.000000000e+00
alter vb dc=9.010357732e-01
option temp=22.941043
op
let idx = 46
wrdata C:/Users/udhav/DVD-Project/work/gate_AND2_4.out idx i(Vdd) i(Va) i(Vb) v(g_nd) v(nand20_x) v(out)
destroy all
altermod nmos vth0=4.743924195e-01
altermod nmos toxe=9.063087858e-10
altermod nmos ndep=6.349423103e+18
altermod nmos u0=3.214103616e-02
altermod nmos xj=5.117204324e-09
altermod pmos vth0=-4.187151149e-01
altermod pmos toxe=9.974528510e-10
altermod pmos ndep=5.859811327e+18
altermod pmos u0=6.093702656e-03
altermod pmos xj=5.007494536e-09
alter vdd dc=1.050595501e+00
alter va dc=0.000000000e+00
alter vb dc=1.050595501e+00
option temp=97.055711
op
let idx = 47
wrdata C:/Users/udhav/DVD-Project/work/gate_AND2_4.out idx i(Vdd) i(Va) i(Vb) v(g_nd) v(nand20_x) v(out)
destroy all
altermod nmos vth0=4.376762039e-01
altermod nmos toxe=9.257332780e-10
altermod nmos ndep=7.491931454e+18
altermod nmos u0=2.735400100e-02
altermod nmos xj=4.946984266e-09
altermod pmos vth0=-4.427180720e-01
altermod pmos toxe=9.909176257e-10
altermod pmos ndep=5.760915039e+18
altermod pmos u0=6.091211305e-03
altermod pmos xj=5.150470191e-09
alter vdd dc=1.062105366e+00
alter va dc=0.000000000e+00
alter vb dc=1.062105366e+00
option temp=111.711452
op
let idx = 48
wrdata C:/Users/udhav/DVD-Project/work/gate_AND2_4.out idx i(Vdd) i(Va) i(Vb) v(g_nd) v(nand20_x) v(out)
destroy all
altermod nmos vth0=4.971968686e-01
altermod nmos toxe=9.579227186e-10
altermod nmos ndep=7.668776448e+18
altermod nmos u0=3.055412867e-02
altermod nmos xj=4.725158319e-09
altermod pmos vth0=-4.626185282e-01
altermod pmos toxe=9.811455936e-10
altermod pmos ndep=5.966163330e+18
altermod pmos u0=6.036692937e-03
altermod pmos xj=5.204382990e-09
alter vdd dc=9.273528103e-01
alter va dc=0.000000000e+00
alter vb dc=9.273528103e-01
option temp=23.926329
op
let idx = 49
wrdata C:/Users/udhav/DVD-Project/work/gate_AND2_4.out idx i(Vdd) i(Va) i(Vb) v(g_nd) v(nand20_x) v(out)
destroy all
altermod nmos vth0=4.552994799e-01
altermod nmos toxe=9.854654709e-10
altermod nmos ndep=6.641789707e+18
altermod nmos u0=3.290199499e-02
altermod nmos xj=5.225877191e-09
altermod pmos vth0=-4.174829786e-01
altermod pmos toxe=9.321808481e-10
altermod pmos ndep=5.022778775e+18
altermod pmos u0=6.282097992e-03
altermod pmos xj=5.321151262e-09
alter vdd dc=9.837807302e-01
alter va dc=0.000000000e+00
alter vb dc=9.837807302e-01
option temp=-17.260335
op
let idx = 50
wrdata C:/Users/udhav/DVD-Project/work/gate_AND2_4.out idx i(Vdd) i(Va) i(Vb) v(g_nd) v(nand20_x) v(out)
destroy all
altermod nmos vth0=4.934022686e-01
altermod nmos toxe=9.612432921e-10
altermod nmos ndep=7.512506859e+18
altermod nmos u0=2.975878458e-02
altermod nmos xj=4.964130307e-09
altermod pmos vth0=-4.045351846e-01
altermod pmos toxe=9.590621055e-10
altermod pmos ndep=5.796579368e+18
altermod pmos u0=5.796252643e-03
altermod pmos xj=4.763219270e-09
alter vdd dc=1.063051256e+00
alter va dc=0.000000000e+00
alter vb dc=1.063051256e+00
option temp=85.461594
op
let idx = 51
wrdata C:/Users/udhav/DVD-Project/work/gate_AND2_4.out idx i(Vdd) i(Va) i(Vb) v(g_nd) v(nand20_x) v(out)
destroy all
altermod nmos vth0=4.678143973e-01
altermod nmos toxe=8.753347566e-10
altermod nmos ndep=6.863543284e+18
altermod nmos u0=3.161739874e-02
altermod nmos xj=5.245379930e-09
altermod pmos vth0=-3.883296588e-01
altermod pmos toxe=9.529783132e-10
altermod pmos ndep=5.459978317e+18
altermod pmos u0=5.996047208e-03
altermod pmos xj=4.578594734e-09
alter vdd dc=9.028542379e-01
alter va dc=0.000000000e+00
alter vb dc=9.028542379e-01
option temp=123.836562
op
let idx = 52
wrdata C:/Users/udhav/DVD-Project/work/gate_AND2_4.out idx i(Vdd) i(Va) i(Vb) v(g_nd) v(nand20_x) v(out)
destroy all
altermod nmos vth0=4.928080965e-01
altermod nmos toxe=1.010398415e-09
altermod nmos ndep=6.735881264e+18
altermod nmos u0=2.758356397e-02
altermod nmos xj=4.864180092e-09
altermod pmos vth0=-3.999447608e-01
altermod pmos toxe=9.496360670e-10
altermod pmos ndep=5.776985277e+18
altermod pmos u0=5.963721374e-03
altermod pmos xj=4.967245751e-09
alter vdd dc=1.025692390e+00
alter va dc=0.000000000e+00
alter vb dc=1.025692390e+00
option temp=-15.581955
op
let idx = 53
wrdata C:/Users/udhav/DVD-Project/work/gate_AND2_4.out idx i(Vdd) i(Va) i(Vb) v(g_nd) v(nand20_x) v(out)
destroy all
altermod nmos vth0=4.564478790e-01
altermod nmos toxe=1.030533346e-09
altermod nmos ndep=7.007216072e+18
altermod nmos u0=3.224104727e-02
altermod nmos xj=4.587789260e-09
altermod pmos vth0=-4.614971441e-01
altermod pmos toxe=1.056564948e-09
altermod pmos ndep=5.275795255e+18
altermod pmos u0=6.193964725e-03
altermod pmos xj=4.670006132e-09
alter vdd dc=1.058604732e+00
alter va dc=0.000000000e+00
alter vb dc=1.058604732e+00
option temp=77.591487
op
let idx = 54
wrdata C:/Users/udhav/DVD-Project/work/gate_AND2_4.out idx i(Vdd) i(Va) i(Vb) v(g_nd) v(nand20_x) v(out)
destroy all
altermod nmos vth0=4.773991966e-01
altermod nmos toxe=8.742456401e-10
altermod nmos ndep=6.311435454e+18
altermod nmos u0=3.049231700e-02
altermod nmos xj=5.042457595e-09
altermod pmos vth0=-4.419544311e-01
altermod pmos toxe=9.228075718e-10
altermod pmos ndep=5.464072106e+18
altermod pmos u0=5.659452914e-03
altermod pmos xj=4.520431909e-09
alter vdd dc=1.002600717e+00
alter va dc=0.000000000e+00
alter vb dc=1.002600717e+00
option temp=96.178361
op
let idx = 55
wrdata C:/Users/udhav/DVD-Project/work/gate_AND2_4.out idx i(Vdd) i(Va) i(Vb) v(g_nd) v(nand20_x) v(out)
destroy all
altermod nmos vth0=4.820170477e-01
altermod nmos toxe=9.024086978e-10
altermod nmos ndep=6.919800257e+18
altermod nmos u0=3.232957912e-02
altermod nmos xj=5.122761359e-09
altermod pmos vth0=-4.735235416e-01
altermod pmos toxe=9.410840685e-10
altermod pmos ndep=5.857049795e+18
altermod pmos u0=5.430089133e-03
altermod pmos xj=5.419684300e-09
alter vdd dc=1.045169884e+00
alter va dc=0.000000000e+00
alter vb dc=1.045169884e+00
option temp=111.894371
op
let idx = 56
wrdata C:/Users/udhav/DVD-Project/work/gate_AND2_4.out idx i(Vdd) i(Va) i(Vb) v(g_nd) v(nand20_x) v(out)
destroy all
altermod nmos vth0=4.922180946e-01
altermod nmos toxe=8.879994258e-10
altermod nmos ndep=6.579376956e+18
altermod nmos u0=3.172270747e-02
altermod nmos xj=5.421777110e-09
altermod pmos vth0=-3.940795238e-01
altermod pmos toxe=1.005282742e-09
altermod pmos ndep=4.988698229e+18
altermod pmos u0=5.506272466e-03
altermod pmos xj=5.126585835e-09
alter vdd dc=9.452846965e-01
alter va dc=0.000000000e+00
alter vb dc=9.452846965e-01
option temp=-19.642067
op
let idx = 57
wrdata C:/Users/udhav/DVD-Project/work/gate_AND2_4.out idx i(Vdd) i(Va) i(Vb) v(g_nd) v(nand20_x) v(out)
destroy all
altermod nmos vth0=4.511748910e-01
altermod nmos toxe=1.016339481e-09
altermod nmos ndep=7.297440071e+18
altermod nmos u0=3.221543865e-02
altermod nmos xj=5.387754745e-09
altermod pmos vth0=-4.196549813e-01
altermod pmos toxe=9.625082924e-10
altermod pmos ndep=5.270239201e+18
altermod pmos u0=5.615090696e-03
altermod pmos xj=4.914364736e-09
alter vdd dc=9.397042296e-01
alter va dc=0.000000000e+00
alter vb dc=9.397042296e-01
option temp=-24.851364
op
let idx = 58
wrdata C:/Users/udhav/DVD-Project/work/gate_AND2_4.out idx i(Vdd) i(Va) i(Vb) v(g_nd) v(nand20_x) v(out)
destroy all
altermod nmos vth0=5.239745596e-01
altermod nmos toxe=1.027952957e-09
altermod nmos ndep=7.003599932e+18
altermod nmos u0=2.734377529e-02
altermod nmos xj=4.557149153e-09
altermod pmos vth0=-4.567125546e-01
altermod pmos toxe=9.480325583e-10
altermod pmos ndep=5.487307974e+18
altermod pmos u0=6.428693647e-03
altermod pmos xj=4.636445089e-09
alter vdd dc=9.726253901e-01
alter va dc=0.000000000e+00
alter vb dc=9.726253901e-01
option temp=122.998811
op
let idx = 59
wrdata C:/Users/udhav/DVD-Project/work/gate_AND2_4.out idx i(Vdd) i(Va) i(Vb) v(g_nd) v(nand20_x) v(out)
destroy all
altermod nmos vth0=4.594220156e-01
altermod nmos toxe=8.634120133e-10
altermod nmos ndep=7.516393682e+18
altermod nmos u0=3.129314465e-02
altermod nmos xj=5.271840387e-09
altermod pmos vth0=-4.451127593e-01
altermod pmos toxe=9.746766045e-10
altermod pmos ndep=5.886652380e+18
altermod pmos u0=6.260204412e-03
altermod pmos xj=5.261248603e-09
alter vdd dc=9.358812055e-01
alter va dc=0.000000000e+00
alter vb dc=9.358812055e-01
option temp=-20.735180
op
let idx = 60
wrdata C:/Users/udhav/DVD-Project/work/gate_AND2_4.out idx i(Vdd) i(Va) i(Vb) v(g_nd) v(nand20_x) v(out)
destroy all
altermod nmos vth0=4.610415112e-01
altermod nmos toxe=9.181596887e-10
altermod nmos ndep=7.555307467e+18
altermod nmos u0=2.818188545e-02
altermod nmos xj=4.761362800e-09
altermod pmos vth0=-3.938388168e-01
altermod pmos toxe=1.000404253e-09
altermod pmos ndep=5.247036514e+18
altermod pmos u0=6.299965209e-03
altermod pmos xj=5.033005246e-09
alter vdd dc=9.692122878e-01
alter va dc=0.000000000e+00
alter vb dc=9.692122878e-01
option temp=-10.826753
op
let idx = 61
wrdata C:/Users/udhav/DVD-Project/work/gate_AND2_4.out idx i(Vdd) i(Va) i(Vb) v(g_nd) v(nand20_x) v(out)
destroy all
altermod nmos vth0=4.562730469e-01
altermod nmos toxe=8.915739765e-10
altermod nmos ndep=6.743462502e+18
altermod nmos u0=2.859486205e-02
altermod nmos xj=5.197198379e-09
altermod pmos vth0=-4.227099884e-01
altermod pmos toxe=1.034867022e-09
altermod pmos ndep=5.855381845e+18
altermod pmos u0=5.933074663e-03
altermod pmos xj=4.674294762e-09
alter vdd dc=1.089624812e+00
alter va dc=0.000000000e+00
alter vb dc=1.089624812e+00
option temp=54.867234
op
let idx = 62
wrdata C:/Users/udhav/DVD-Project/work/gate_AND2_4.out idx i(Vdd) i(Va) i(Vb) v(g_nd) v(nand20_x) v(out)
destroy all
altermod nmos vth0=4.381579977e-01
altermod nmos toxe=9.442112143e-10
altermod nmos ndep=6.692537328e+18
altermod nmos u0=2.894869728e-02
altermod nmos xj=4.879481968e-09
altermod pmos vth0=-4.430797117e-01
altermod pmos toxe=1.094444420e-09
altermod pmos ndep=5.218998888e+18
altermod pmos u0=5.523325397e-03
altermod pmos xj=5.482271824e-09
alter vdd dc=1.014666544e+00
alter va dc=0.000000000e+00
alter vb dc=1.014666544e+00
option temp=33.635051
op
let idx = 63
wrdata C:/Users/udhav/DVD-Project/work/gate_AND2_4.out idx i(Vdd) i(Va) i(Vb) v(g_nd) v(nand20_x) v(out)
destroy all
altermod nmos vth0=4.722559950e-01
altermod nmos toxe=1.030102181e-09
altermod nmos ndep=7.614782537e+18
altermod nmos u0=3.054788791e-02
altermod nmos xj=4.822078355e-09
altermod pmos vth0=-4.474023140e-01
altermod pmos toxe=1.070527762e-09
altermod pmos ndep=5.283466041e+18
altermod pmos u0=5.958327839e-03
altermod pmos xj=5.450814710e-09
alter vdd dc=9.680136135e-01
alter va dc=0.000000000e+00
alter vb dc=9.680136135e-01
option temp=83.814712
op
let idx = 64
wrdata C:/Users/udhav/DVD-Project/work/gate_AND2_4.out idx i(Vdd) i(Va) i(Vb) v(g_nd) v(nand20_x) v(out)
destroy all
altermod nmos vth0=5.057272573e-01
altermod nmos toxe=8.683329159e-10
altermod nmos ndep=7.005596583e+18
altermod nmos u0=3.076716550e-02
altermod nmos xj=4.988283729e-09
altermod pmos vth0=-4.270437547e-01
altermod pmos toxe=9.859984801e-10
altermod pmos ndep=5.559199900e+18
altermod pmos u0=6.435584239e-03
altermod pmos xj=5.427141110e-09
alter vdd dc=9.543049240e-01
alter va dc=0.000000000e+00
alter vb dc=9.543049240e-01
option temp=-8.558054
op
let idx = 65
wrdata C:/Users/udhav/DVD-Project/work/gate_AND2_4.out idx i(Vdd) i(Va) i(Vb) v(g_nd) v(nand20_x) v(out)
destroy all
altermod nmos vth0=4.997537562e-01
altermod nmos toxe=8.875430315e-10
altermod nmos ndep=6.435121737e+18
altermod nmos u0=3.258865527e-02
altermod nmos xj=5.030531158e-09
altermod pmos vth0=-4.043169488e-01
altermod pmos toxe=9.903274079e-10
altermod pmos ndep=5.669295723e+18
altermod pmos u0=6.010985926e-03
altermod pmos xj=5.326649234e-09
alter vdd dc=1.090407898e+00
alter va dc=0.000000000e+00
alter vb dc=1.090407898e+00
option temp=110.880581
op
let idx = 66
wrdata C:/Users/udhav/DVD-Project/work/gate_AND2_4.out idx i(Vdd) i(Va) i(Vb) v(g_nd) v(nand20_x) v(out)
destroy all
.endc
.end
