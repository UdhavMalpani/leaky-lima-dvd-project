* c
.include C:/Users/udhav/DVD-Project/models/16nm_HP.pm
.options gmin=1e-18 abstol=1e-18 reltol=1e-6 vntol=1e-9
M1 d g s b pmos W=1.600000000e-08 L=1.600000000e-08
Vd d 0 0
Vg g 0 0
Vs s 0 0
Vb b 0 0
.control
set appendwrite
set wr_vecnames=0
altermod pmos vth0=-4.114052018e-01
altermod pmos toxe=9.128919589e-10
altermod pmos ndep=5.999760117e+18
altermod pmos u0=5.453280303e-03
altermod pmos xj=4.585414221e-09
alter m1 w=1.113456678e-07
alter vd dc=6.741467257e-01
alter vg dc=1.016446612e+00
alter vs dc=2.117726209e-01
alter vb dc=1.016446612e+00
option temp=104.977126
op
let idx = 0
wrdata C:/Users/udhav/DVD-Project/work/comp_pmos_off_10.out idx i(Vd) i(Vg) i(Vs) i(Vb) @m1[id] @m1[igs] @m1[igd] @m1[igcs] @m1[igcd] @m1[igb] @m1[igidl] @m1[igisl] @m1[isub] @m1[ibd] @m1[ibs]
destroy all
altermod pmos vth0=-4.284474875e-01
altermod pmos toxe=9.775886582e-10
altermod pmos ndep=5.870253769e+18
altermod pmos u0=6.105424033e-03
altermod pmos xj=4.950860483e-09
alter m1 w=6.388653312e-08
alter vd dc=1.039330965e-01
alter vg dc=1.005744930e+00
alter vs dc=2.456007551e-01
alter vb dc=1.005744930e+00
option temp=36.085504
op
let idx = 1
wrdata C:/Users/udhav/DVD-Project/work/comp_pmos_off_10.out idx i(Vd) i(Vg) i(Vs) i(Vb) @m1[id] @m1[igs] @m1[igd] @m1[igcs] @m1[igcd] @m1[igb] @m1[igidl] @m1[igisl] @m1[isub] @m1[ibd] @m1[ibs]
destroy all
altermod pmos vth0=-3.894019413e-01
altermod pmos toxe=9.905510796e-10
altermod pmos ndep=4.994327030e+18
altermod pmos u0=6.527147265e-03
altermod pmos xj=5.266657454e-09
alter m1 w=9.954482386e-08
alter vd dc=5.792260906e-01
alter vg dc=1.070873439e+00
alter vs dc=7.579872702e-01
alter vb dc=1.070873439e+00
option temp=94.638263
op
let idx = 2
wrdata C:/Users/udhav/DVD-Project/work/comp_pmos_off_10.out idx i(Vd) i(Vg) i(Vs) i(Vb) @m1[id] @m1[igs] @m1[igd] @m1[igcs] @m1[igcd] @m1[igb] @m1[igidl] @m1[igisl] @m1[isub] @m1[ibd] @m1[ibs]
destroy all
altermod pmos vth0=-4.286257773e-01
altermod pmos toxe=9.568843990e-10
altermod pmos ndep=5.265700584e+18
altermod pmos u0=6.277613476e-03
altermod pmos xj=4.510498853e-09
alter m1 w=4.121522485e-08
alter vd dc=5.840522720e-01
alter vg dc=1.098571095e+00
alter vs dc=1.552517508e-01
alter vb dc=1.098571095e+00
option temp=89.075246
op
let idx = 3
wrdata C:/Users/udhav/DVD-Project/work/comp_pmos_off_10.out idx i(Vd) i(Vg) i(Vs) i(Vb) @m1[id] @m1[igs] @m1[igd] @m1[igcs] @m1[igcd] @m1[igb] @m1[igidl] @m1[igisl] @m1[isub] @m1[ibd] @m1[ibs]
destroy all
altermod pmos vth0=-4.440476755e-01
altermod pmos toxe=9.855904079e-10
altermod pmos ndep=5.758150021e+18
altermod pmos u0=5.515412382e-03
altermod pmos xj=5.370739340e-09
alter m1 w=8.900039636e-08
alter vd dc=8.372135930e-01
alter vg dc=9.042200281e-01
alter vs dc=9.506360476e-02
alter vb dc=9.042200281e-01
option temp=57.977603
op
let idx = 4
wrdata C:/Users/udhav/DVD-Project/work/comp_pmos_off_10.out idx i(Vd) i(Vg) i(Vs) i(Vb) @m1[id] @m1[igs] @m1[igd] @m1[igcs] @m1[igcd] @m1[igb] @m1[igidl] @m1[igisl] @m1[isub] @m1[ibd] @m1[ibs]
destroy all
altermod pmos vth0=-4.381116848e-01
altermod pmos toxe=9.099005932e-10
altermod pmos ndep=5.524466895e+18
altermod pmos u0=5.799272375e-03
altermod pmos xj=5.374260547e-09
alter m1 w=3.439817420e-08
alter vd dc=5.988975764e-01
alter vg dc=9.596702584e-01
alter vs dc=5.855214481e-01
alter vb dc=9.596702584e-01
option temp=63.005638
op
let idx = 5
wrdata C:/Users/udhav/DVD-Project/work/comp_pmos_off_10.out idx i(Vd) i(Vg) i(Vs) i(Vb) @m1[id] @m1[igs] @m1[igd] @m1[igcs] @m1[igcd] @m1[igb] @m1[igidl] @m1[igisl] @m1[isub] @m1[ibd] @m1[ibs]
destroy all
altermod pmos vth0=-4.040322488e-01
altermod pmos toxe=9.797117145e-10
altermod pmos ndep=5.506425727e+18
altermod pmos u0=6.009714379e-03
altermod pmos xj=4.940554255e-09
alter m1 w=2.394032875e-08
alter vd dc=9.005459375e-01
alter vg dc=9.234290837e-01
alter vs dc=7.697209129e-03
alter vb dc=9.234290837e-01
option temp=11.818910
op
let idx = 6
wrdata C:/Users/udhav/DVD-Project/work/comp_pmos_off_10.out idx i(Vd) i(Vg) i(Vs) i(Vb) @m1[id] @m1[igs] @m1[igd] @m1[igcs] @m1[igcd] @m1[igb] @m1[igidl] @m1[igisl] @m1[isub] @m1[ibd] @m1[ibs]
destroy all
altermod pmos vth0=-4.469635822e-01
altermod pmos toxe=1.075159005e-09
altermod pmos ndep=5.314374049e+18
altermod pmos u0=6.379487652e-03
altermod pmos xj=5.144956745e-09
alter m1 w=9.225164092e-08
alter vd dc=6.147815077e-01
alter vg dc=1.097249035e+00
alter vs dc=6.204792270e-01
alter vb dc=1.097249035e+00
option temp=98.744399
op
let idx = 7
wrdata C:/Users/udhav/DVD-Project/work/comp_pmos_off_10.out idx i(Vd) i(Vg) i(Vs) i(Vb) @m1[id] @m1[igs] @m1[igd] @m1[igcs] @m1[igcd] @m1[igb] @m1[igidl] @m1[igisl] @m1[isub] @m1[ibd] @m1[ibs]
destroy all
altermod pmos vth0=-4.226035007e-01
altermod pmos toxe=9.836501864e-10
altermod pmos ndep=6.042062088e+18
altermod pmos u0=5.963902297e-03
altermod pmos xj=5.072745237e-09
alter m1 w=8.956636094e-08
alter vd dc=4.243151242e-01
alter vg dc=1.027434061e+00
alter vs dc=9.780918716e-01
alter vb dc=1.027434061e+00
option temp=45.407780
op
let idx = 8
wrdata C:/Users/udhav/DVD-Project/work/comp_pmos_off_10.out idx i(Vd) i(Vg) i(Vs) i(Vb) @m1[id] @m1[igs] @m1[igd] @m1[igcs] @m1[igcd] @m1[igb] @m1[igidl] @m1[igisl] @m1[isub] @m1[ibd] @m1[ibs]
destroy all
altermod pmos vth0=-3.979697473e-01
altermod pmos toxe=1.089761974e-09
altermod pmos ndep=5.981372007e+18
altermod pmos u0=6.091483892e-03
altermod pmos xj=5.296203373e-09
alter m1 w=3.552177689e-08
alter vd dc=4.723619349e-01
alter vg dc=1.088705431e+00
alter vs dc=1.068434404e+00
alter vb dc=1.088705431e+00
option temp=50.063321
op
let idx = 9
wrdata C:/Users/udhav/DVD-Project/work/comp_pmos_off_10.out idx i(Vd) i(Vg) i(Vs) i(Vb) @m1[id] @m1[igs] @m1[igd] @m1[igcs] @m1[igcd] @m1[igb] @m1[igidl] @m1[igisl] @m1[isub] @m1[ibd] @m1[ibs]
destroy all
altermod pmos vth0=-4.191841457e-01
altermod pmos toxe=1.077080720e-09
altermod pmos ndep=5.546351463e+18
altermod pmos u0=5.546301270e-03
altermod pmos xj=4.890357538e-09
alter m1 w=6.096463286e-08
alter vd dc=7.138728805e-01
alter vg dc=1.074547369e+00
alter vs dc=8.714079166e-01
alter vb dc=1.074547369e+00
option temp=92.549263
op
let idx = 10
wrdata C:/Users/udhav/DVD-Project/work/comp_pmos_off_10.out idx i(Vd) i(Vg) i(Vs) i(Vb) @m1[id] @m1[igs] @m1[igd] @m1[igcs] @m1[igcd] @m1[igb] @m1[igidl] @m1[igisl] @m1[isub] @m1[ibd] @m1[ibs]
destroy all
altermod pmos vth0=-4.532726812e-01
altermod pmos toxe=1.068069412e-09
altermod pmos ndep=5.637619715e+18
altermod pmos u0=5.833222211e-03
altermod pmos xj=4.616289363e-09
alter m1 w=8.801218049e-08
alter vd dc=2.989268728e-01
alter vg dc=1.000171854e+00
alter vs dc=5.716773210e-01
alter vb dc=1.000171854e+00
option temp=3.187603
op
let idx = 11
wrdata C:/Users/udhav/DVD-Project/work/comp_pmos_off_10.out idx i(Vd) i(Vg) i(Vs) i(Vb) @m1[id] @m1[igs] @m1[igd] @m1[igcs] @m1[igcd] @m1[igb] @m1[igidl] @m1[igisl] @m1[isub] @m1[ibd] @m1[ibs]
destroy all
altermod pmos vth0=-4.430839114e-01
altermod pmos toxe=9.633833451e-10
altermod pmos ndep=5.100896076e+18
altermod pmos u0=5.627255729e-03
altermod pmos xj=5.303215928e-09
alter m1 w=5.397342276e-08
alter vd dc=2.799015397e-01
alter vg dc=9.829528277e-01
alter vs dc=2.550109859e-01
alter vb dc=9.829528277e-01
option temp=119.282147
op
let idx = 12
wrdata C:/Users/udhav/DVD-Project/work/comp_pmos_off_10.out idx i(Vd) i(Vg) i(Vs) i(Vb) @m1[id] @m1[igs] @m1[igd] @m1[igcs] @m1[igcd] @m1[igb] @m1[igidl] @m1[igisl] @m1[isub] @m1[ibd] @m1[ibs]
destroy all
altermod pmos vth0=-3.928232278e-01
altermod pmos toxe=9.793249531e-10
altermod pmos ndep=5.341465531e+18
altermod pmos u0=6.014215987e-03
altermod pmos xj=5.195224974e-09
alter m1 w=8.978022358e-08
alter vd dc=6.071300569e-01
alter vg dc=1.017657619e+00
alter vs dc=9.342223792e-02
alter vb dc=1.017657619e+00
option temp=123.753890
op
let idx = 13
wrdata C:/Users/udhav/DVD-Project/work/comp_pmos_off_10.out idx i(Vd) i(Vg) i(Vs) i(Vb) @m1[id] @m1[igs] @m1[igd] @m1[igcs] @m1[igcd] @m1[igb] @m1[igidl] @m1[igisl] @m1[isub] @m1[ibd] @m1[ibs]
destroy all
altermod pmos vth0=-3.903916227e-01
altermod pmos toxe=1.029026324e-09
altermod pmos ndep=5.520652883e+18
altermod pmos u0=6.144717808e-03
altermod pmos xj=5.082837627e-09
alter m1 w=1.022711140e-07
alter vd dc=6.190933770e-01
alter vg dc=1.064979322e+00
alter vs dc=6.965042957e-01
alter vb dc=1.064979322e+00
option temp=86.352386
op
let idx = 14
wrdata C:/Users/udhav/DVD-Project/work/comp_pmos_off_10.out idx i(Vd) i(Vg) i(Vs) i(Vb) @m1[id] @m1[igs] @m1[igd] @m1[igcs] @m1[igcd] @m1[igb] @m1[igidl] @m1[igisl] @m1[isub] @m1[ibd] @m1[ibs]
destroy all
altermod pmos vth0=-4.402831337e-01
altermod pmos toxe=9.614340876e-10
altermod pmos ndep=5.189988512e+18
altermod pmos u0=5.983881925e-03
altermod pmos xj=4.699973888e-09
alter m1 w=1.256963639e-07
alter vd dc=6.615483758e-01
alter vg dc=1.015694018e+00
alter vs dc=4.195070119e-01
alter vb dc=1.015694018e+00
option temp=87.948910
op
let idx = 15
wrdata C:/Users/udhav/DVD-Project/work/comp_pmos_off_10.out idx i(Vd) i(Vg) i(Vs) i(Vb) @m1[id] @m1[igs] @m1[igd] @m1[igcs] @m1[igcd] @m1[igb] @m1[igidl] @m1[igisl] @m1[isub] @m1[ibd] @m1[ibs]
destroy all
altermod pmos vth0=-3.993553188e-01
altermod pmos toxe=9.722174673e-10
altermod pmos ndep=5.756999872e+18
altermod pmos u0=6.492124579e-03
altermod pmos xj=4.617717574e-09
alter m1 w=8.895363039e-08
alter vd dc=8.889187734e-01
alter vg dc=1.066938706e+00
alter vs dc=1.048870007e+00
alter vb dc=1.066938706e+00
option temp=-32.091697
op
let idx = 16
wrdata C:/Users/udhav/DVD-Project/work/comp_pmos_off_10.out idx i(Vd) i(Vg) i(Vs) i(Vb) @m1[id] @m1[igs] @m1[igd] @m1[igcs] @m1[igcd] @m1[igb] @m1[igidl] @m1[igisl] @m1[isub] @m1[ibd] @m1[ibs]
destroy all
altermod pmos vth0=-4.150837743e-01
altermod pmos toxe=1.078866952e-09
altermod pmos ndep=5.884650365e+18
altermod pmos u0=6.419815406e-03
altermod pmos xj=5.277388733e-09
alter m1 w=8.090253325e-08
alter vd dc=3.221176449e-01
alter vg dc=1.010901104e+00
alter vs dc=1.043919372e-01
alter vb dc=1.010901104e+00
option temp=113.889804
op
let idx = 17
wrdata C:/Users/udhav/DVD-Project/work/comp_pmos_off_10.out idx i(Vd) i(Vg) i(Vs) i(Vb) @m1[id] @m1[igs] @m1[igd] @m1[igcs] @m1[igcd] @m1[igb] @m1[igidl] @m1[igisl] @m1[isub] @m1[ibd] @m1[ibs]
destroy all
altermod pmos vth0=-4.407327715e-01
altermod pmos toxe=1.059893953e-09
altermod pmos ndep=5.905075875e+18
altermod pmos u0=5.975240272e-03
altermod pmos xj=5.285559440e-09
alter m1 w=7.521697405e-08
alter vd dc=7.198136608e-01
alter vg dc=9.386504902e-01
alter vs dc=9.244846386e-01
alter vb dc=9.386504902e-01
option temp=-37.361538
op
let idx = 18
wrdata C:/Users/udhav/DVD-Project/work/comp_pmos_off_10.out idx i(Vd) i(Vg) i(Vs) i(Vb) @m1[id] @m1[igs] @m1[igd] @m1[igcs] @m1[igcd] @m1[igb] @m1[igidl] @m1[igisl] @m1[isub] @m1[ibd] @m1[ibs]
destroy all
altermod pmos vth0=-4.498554078e-01
altermod pmos toxe=9.914689329e-10
altermod pmos ndep=5.714831346e+18
altermod pmos u0=6.531385058e-03
altermod pmos xj=4.890672241e-09
alter m1 w=1.044528293e-07
alter vd dc=6.788573139e-01
alter vg dc=1.062840531e+00
alter vs dc=2.390905879e-01
alter vb dc=1.062840531e+00
option temp=-17.265442
op
let idx = 19
wrdata C:/Users/udhav/DVD-Project/work/comp_pmos_off_10.out idx i(Vd) i(Vg) i(Vs) i(Vb) @m1[id] @m1[igs] @m1[igd] @m1[igcs] @m1[igcd] @m1[igb] @m1[igidl] @m1[igisl] @m1[isub] @m1[ibd] @m1[ibs]
destroy all
altermod pmos vth0=-4.471918823e-01
altermod pmos toxe=9.909503445e-10
altermod pmos ndep=5.586244222e+18
altermod pmos u0=5.680686091e-03
altermod pmos xj=5.100904827e-09
alter m1 w=3.600110280e-08
alter vd dc=3.866901094e-01
alter vg dc=9.144196453e-01
alter vs dc=8.530846420e-01
alter vb dc=9.144196453e-01
option temp=90.167602
op
let idx = 20
wrdata C:/Users/udhav/DVD-Project/work/comp_pmos_off_10.out idx i(Vd) i(Vg) i(Vs) i(Vb) @m1[id] @m1[igs] @m1[igd] @m1[igcs] @m1[igcd] @m1[igb] @m1[igidl] @m1[igisl] @m1[isub] @m1[ibd] @m1[ibs]
destroy all
altermod pmos vth0=-4.390183520e-01
altermod pmos toxe=9.150573779e-10
altermod pmos ndep=5.446793573e+18
altermod pmos u0=6.156317784e-03
altermod pmos xj=5.396952943e-09
alter m1 w=9.356283480e-08
alter vd dc=1.412222207e-01
alter vg dc=9.464607704e-01
alter vs dc=2.544074457e-01
alter vb dc=9.464607704e-01
option temp=21.575326
op
let idx = 21
wrdata C:/Users/udhav/DVD-Project/work/comp_pmos_off_10.out idx i(Vd) i(Vg) i(Vs) i(Vb) @m1[id] @m1[igs] @m1[igd] @m1[igcs] @m1[igcd] @m1[igb] @m1[igidl] @m1[igisl] @m1[isub] @m1[ibd] @m1[ibs]
destroy all
altermod pmos vth0=-4.582989709e-01
altermod pmos toxe=1.008640589e-09
altermod pmos ndep=5.508048955e+18
altermod pmos u0=5.928186807e-03
altermod pmos xj=4.504412118e-09
alter m1 w=4.942927717e-08
alter vd dc=8.288571568e-01
alter vg dc=9.846157778e-01
alter vs dc=3.589034264e-01
alter vb dc=9.846157778e-01
option temp=36.539608
op
let idx = 22
wrdata C:/Users/udhav/DVD-Project/work/comp_pmos_off_10.out idx i(Vd) i(Vg) i(Vs) i(Vb) @m1[id] @m1[igs] @m1[igd] @m1[igcs] @m1[igcd] @m1[igb] @m1[igidl] @m1[igisl] @m1[isub] @m1[ibd] @m1[ibs]
destroy all
altermod pmos vth0=-4.555851110e-01
altermod pmos toxe=1.021576481e-09
altermod pmos ndep=5.119238161e+18
altermod pmos u0=5.701798408e-03
altermod pmos xj=5.005710582e-09
alter m1 w=6.035329010e-08
alter vd dc=5.105575726e-01
alter vg dc=9.088817223e-01
alter vs dc=2.321903602e-01
alter vb dc=9.088817223e-01
option temp=41.383974
op
let idx = 23
wrdata C:/Users/udhav/DVD-Project/work/comp_pmos_off_10.out idx i(Vd) i(Vg) i(Vs) i(Vb) @m1[id] @m1[igs] @m1[igd] @m1[igcs] @m1[igcd] @m1[igb] @m1[igidl] @m1[igisl] @m1[isub] @m1[ibd] @m1[ibs]
destroy all
altermod pmos vth0=-4.652655173e-01
altermod pmos toxe=1.059062482e-09
altermod pmos ndep=5.735911977e+18
altermod pmos u0=6.105520364e-03
altermod pmos xj=5.478214372e-09
alter m1 w=5.058536756e-08
alter vd dc=7.626732095e-01
alter vg dc=9.725761432e-01
alter vs dc=2.967354849e-01
alter vb dc=9.725761432e-01
option temp=33.565696
op
let idx = 24
wrdata C:/Users/udhav/DVD-Project/work/comp_pmos_off_10.out idx i(Vd) i(Vg) i(Vs) i(Vb) @m1[id] @m1[igs] @m1[igd] @m1[igcs] @m1[igcd] @m1[igb] @m1[igidl] @m1[igisl] @m1[isub] @m1[ibd] @m1[ibs]
destroy all
altermod pmos vth0=-4.629032517e-01
altermod pmos toxe=9.300120154e-10
altermod pmos ndep=5.092384022e+18
altermod pmos u0=5.738977613e-03
altermod pmos xj=4.713388849e-09
alter m1 w=8.404465437e-08
alter vd dc=1.224318934e-01
alter vg dc=1.036997543e+00
alter vs dc=8.146885405e-01
alter vb dc=1.036997543e+00
option temp=121.822192
op
let idx = 25
wrdata C:/Users/udhav/DVD-Project/work/comp_pmos_off_10.out idx i(Vd) i(Vg) i(Vs) i(Vb) @m1[id] @m1[igs] @m1[igd] @m1[igcs] @m1[igcd] @m1[igb] @m1[igidl] @m1[igisl] @m1[isub] @m1[ibd] @m1[ibs]
destroy all
altermod pmos vth0=-4.397021405e-01
altermod pmos toxe=9.168859310e-10
altermod pmos ndep=5.328766354e+18
altermod pmos u0=5.987974678e-03
altermod pmos xj=5.092660449e-09
alter m1 w=7.267111852e-08
alter vd dc=3.466328824e-01
alter vg dc=9.045564273e-01
alter vs dc=8.010941513e-01
alter vb dc=9.045564273e-01
option temp=76.475243
op
let idx = 26
wrdata C:/Users/udhav/DVD-Project/work/comp_pmos_off_10.out idx i(Vd) i(Vg) i(Vs) i(Vb) @m1[id] @m1[igs] @m1[igd] @m1[igcs] @m1[igcd] @m1[igb] @m1[igidl] @m1[igisl] @m1[isub] @m1[ibd] @m1[ibs]
destroy all
altermod pmos vth0=-4.244451717e-01
altermod pmos toxe=9.255188959e-10
altermod pmos ndep=5.997731720e+18
altermod pmos u0=6.189475129e-03
altermod pmos xj=5.090897047e-09
alter m1 w=5.572553847e-08
alter vd dc=7.516809900e-01
alter vg dc=9.959187836e-01
alter vs dc=2.508589664e-01
alter vb dc=9.959187836e-01
option temp=82.528977
op
let idx = 27
wrdata C:/Users/udhav/DVD-Project/work/comp_pmos_off_10.out idx i(Vd) i(Vg) i(Vs) i(Vb) @m1[id] @m1[igs] @m1[igd] @m1[igcs] @m1[igcd] @m1[igb] @m1[igidl] @m1[igisl] @m1[isub] @m1[ibd] @m1[ibs]
destroy all
altermod pmos vth0=-4.581603383e-01
altermod pmos toxe=9.560825133e-10
altermod pmos ndep=4.998534335e+18
altermod pmos u0=6.041622803e-03
altermod pmos xj=4.603874460e-09
alter m1 w=1.125680883e-07
alter vd dc=1.023386735e+00
alter vg dc=1.070950125e+00
alter vs dc=8.970097966e-01
alter vb dc=1.070950125e+00
option temp=-33.624924
op
let idx = 28
wrdata C:/Users/udhav/DVD-Project/work/comp_pmos_off_10.out idx i(Vd) i(Vg) i(Vs) i(Vb) @m1[id] @m1[igs] @m1[igd] @m1[igcs] @m1[igcd] @m1[igb] @m1[igidl] @m1[igisl] @m1[isub] @m1[ibd] @m1[ibs]
destroy all
altermod pmos vth0=-4.518193655e-01
altermod pmos toxe=1.050905081e-09
altermod pmos ndep=5.633170982e+18
altermod pmos u0=5.798310163e-03
altermod pmos xj=4.979826892e-09
alter m1 w=3.646376424e-08
alter vd dc=2.581818542e-01
alter vg dc=1.049032200e+00
alter vs dc=3.819682151e-01
alter vb dc=1.049032200e+00
option temp=50.730204
op
let idx = 29
wrdata C:/Users/udhav/DVD-Project/work/comp_pmos_off_10.out idx i(Vd) i(Vg) i(Vs) i(Vb) @m1[id] @m1[igs] @m1[igd] @m1[igcs] @m1[igcd] @m1[igb] @m1[igidl] @m1[igisl] @m1[isub] @m1[ibd] @m1[ibs]
destroy all
altermod pmos vth0=-4.520281672e-01
altermod pmos toxe=1.023990554e-09
altermod pmos ndep=5.476692916e+18
altermod pmos u0=6.151492698e-03
altermod pmos xj=4.844842456e-09
alter m1 w=8.723498546e-08
alter vd dc=2.855982769e-01
alter vg dc=9.347753454e-01
alter vs dc=7.982981262e-01
alter vb dc=9.347753454e-01
option temp=41.349037
op
let idx = 30
wrdata C:/Users/udhav/DVD-Project/work/comp_pmos_off_10.out idx i(Vd) i(Vg) i(Vs) i(Vb) @m1[id] @m1[igs] @m1[igd] @m1[igcs] @m1[igcd] @m1[igb] @m1[igidl] @m1[igisl] @m1[isub] @m1[ibd] @m1[ibs]
destroy all
altermod pmos vth0=-4.152376842e-01
altermod pmos toxe=9.155682513e-10
altermod pmos ndep=5.637677667e+18
altermod pmos u0=5.492493281e-03
altermod pmos xj=4.998165037e-09
alter m1 w=2.407934396e-08
alter vd dc=5.021842265e-01
alter vg dc=9.052798227e-01
alter vs dc=5.311968940e-02
alter vb dc=9.052798227e-01
option temp=39.293473
op
let idx = 31
wrdata C:/Users/udhav/DVD-Project/work/comp_pmos_off_10.out idx i(Vd) i(Vg) i(Vs) i(Vb) @m1[id] @m1[igs] @m1[igd] @m1[igcs] @m1[igcd] @m1[igb] @m1[igidl] @m1[igisl] @m1[isub] @m1[ibd] @m1[ibs]
destroy all
altermod pmos vth0=-4.304342123e-01
altermod pmos toxe=1.019038695e-09
altermod pmos ndep=5.580262661e+18
altermod pmos u0=5.535534770e-03
altermod pmos xj=5.136392419e-09
alter m1 w=1.210566009e-07
alter vd dc=4.351811177e-01
alter vg dc=9.715880344e-01
alter vs dc=5.237957069e-02
alter vb dc=9.715880344e-01
option temp=82.700218
op
let idx = 32
wrdata C:/Users/udhav/DVD-Project/work/comp_pmos_off_10.out idx i(Vd) i(Vg) i(Vs) i(Vb) @m1[id] @m1[igs] @m1[igd] @m1[igcs] @m1[igcd] @m1[igb] @m1[igidl] @m1[igisl] @m1[isub] @m1[ibd] @m1[ibs]
destroy all
altermod pmos vth0=-4.500818693e-01
altermod pmos toxe=1.013804106e-09
altermod pmos ndep=5.726354992e+18
altermod pmos u0=5.633265766e-03
altermod pmos xj=5.475640904e-09
alter m1 w=1.042117798e-07
alter vd dc=4.924420300e-01
alter vg dc=1.096863700e+00
alter vs dc=6.386069224e-01
alter vb dc=1.096863700e+00
option temp=-18.549283
op
let idx = 33
wrdata C:/Users/udhav/DVD-Project/work/comp_pmos_off_10.out idx i(Vd) i(Vg) i(Vs) i(Vb) @m1[id] @m1[igs] @m1[igd] @m1[igcs] @m1[igcd] @m1[igb] @m1[igidl] @m1[igisl] @m1[isub] @m1[ibd] @m1[ibs]
destroy all
altermod pmos vth0=-4.486823684e-01
altermod pmos toxe=9.993500899e-10
altermod pmos ndep=5.870956359e+18
altermod pmos u0=6.282886087e-03
altermod pmos xj=4.888992845e-09
alter m1 w=7.329818402e-08
alter vd dc=2.729731598e-01
alter vg dc=1.053901963e+00
alter vs dc=5.471635271e-01
alter vb dc=1.053901963e+00
option temp=43.047222
op
let idx = 34
wrdata C:/Users/udhav/DVD-Project/work/comp_pmos_off_10.out idx i(Vd) i(Vg) i(Vs) i(Vb) @m1[id] @m1[igs] @m1[igd] @m1[igcs] @m1[igcd] @m1[igb] @m1[igidl] @m1[igisl] @m1[isub] @m1[ibd] @m1[ibs]
destroy all
altermod pmos vth0=-4.061392265e-01
altermod pmos toxe=9.463364011e-10
altermod pmos ndep=6.005338251e+18
altermod pmos u0=6.247197685e-03
altermod pmos xj=5.202975446e-09
alter m1 w=4.453267869e-08
alter vd dc=1.133041480e-01
alter vg dc=1.012066374e+00
alter vs dc=3.404439995e-01
alter vb dc=1.012066374e+00
option temp=-4.973807
op
let idx = 35
wrdata C:/Users/udhav/DVD-Project/work/comp_pmos_off_10.out idx i(Vd) i(Vg) i(Vs) i(Vb) @m1[id] @m1[igs] @m1[igd] @m1[igcs] @m1[igcd] @m1[igb] @m1[igidl] @m1[igisl] @m1[isub] @m1[ibd] @m1[ibs]
destroy all
altermod pmos vth0=-4.151564395e-01
altermod pmos toxe=1.016464155e-09
altermod pmos ndep=5.689306406e+18
altermod pmos u0=5.803732377e-03
altermod pmos xj=5.217152612e-09
alter m1 w=1.076673113e-07
alter vd dc=6.959503453e-01
alter vg dc=9.909847352e-01
alter vs dc=6.952449862e-01
alter vb dc=9.909847352e-01
option temp=-27.558830
op
let idx = 36
wrdata C:/Users/udhav/DVD-Project/work/comp_pmos_off_10.out idx i(Vd) i(Vg) i(Vs) i(Vb) @m1[id] @m1[igs] @m1[igd] @m1[igcs] @m1[igcd] @m1[igb] @m1[igidl] @m1[igisl] @m1[isub] @m1[ibd] @m1[ibs]
destroy all
altermod pmos vth0=-4.207269231e-01
altermod pmos toxe=1.026727156e-09
altermod pmos ndep=5.007945992e+18
altermod pmos u0=6.103872428e-03
altermod pmos xj=4.772212890e-09
alter m1 w=6.730613149e-08
alter vd dc=7.004031519e-01
alter vg dc=1.016748454e+00
alter vs dc=8.258219789e-01
alter vb dc=1.016748454e+00
option temp=-16.961143
op
let idx = 37
wrdata C:/Users/udhav/DVD-Project/work/comp_pmos_off_10.out idx i(Vd) i(Vg) i(Vs) i(Vb) @m1[id] @m1[igs] @m1[igd] @m1[igcs] @m1[igcd] @m1[igb] @m1[igidl] @m1[igisl] @m1[isub] @m1[ibd] @m1[ibs]
destroy all
altermod pmos vth0=-4.339841454e-01
altermod pmos toxe=1.005097110e-09
altermod pmos ndep=6.029641870e+18
altermod pmos u0=6.309660941e-03
altermod pmos xj=5.055548326e-09
alter m1 w=2.239776746e-08
alter vd dc=1.411390047e-01
alter vg dc=1.087110564e+00
alter vs dc=1.008271414e+00
alter vb dc=1.087110564e+00
option temp=-15.029879
op
let idx = 38
wrdata C:/Users/udhav/DVD-Project/work/comp_pmos_off_10.out idx i(Vd) i(Vg) i(Vs) i(Vb) @m1[id] @m1[igs] @m1[igd] @m1[igcs] @m1[igcd] @m1[igb] @m1[igidl] @m1[igisl] @m1[isub] @m1[ibd] @m1[ibs]
destroy all
altermod pmos vth0=-4.039436951e-01
altermod pmos toxe=1.051417672e-09
altermod pmos ndep=5.760179070e+18
altermod pmos u0=6.584358916e-03
altermod pmos xj=4.697381935e-09
alter m1 w=6.650483803e-08
alter vd dc=3.729433253e-01
alter vg dc=9.042638565e-01
alter vs dc=1.774151554e-01
alter vb dc=9.042638565e-01
option temp=37.248416
op
let idx = 39
wrdata C:/Users/udhav/DVD-Project/work/comp_pmos_off_10.out idx i(Vd) i(Vg) i(Vs) i(Vb) @m1[id] @m1[igs] @m1[igd] @m1[igcs] @m1[igcd] @m1[igb] @m1[igidl] @m1[igisl] @m1[isub] @m1[ibd] @m1[ibs]
destroy all
altermod pmos vth0=-4.727781295e-01
altermod pmos toxe=1.026607965e-09
altermod pmos ndep=5.348121773e+18
altermod pmos u0=6.555607039e-03
altermod pmos xj=5.354173434e-09
alter m1 w=1.184913618e-07
alter vd dc=2.121180268e-01
alter vg dc=9.285058365e-01
alter vs dc=7.742324830e-01
alter vb dc=9.285058365e-01
option temp=75.097584
op
let idx = 40
wrdata C:/Users/udhav/DVD-Project/work/comp_pmos_off_10.out idx i(Vd) i(Vg) i(Vs) i(Vb) @m1[id] @m1[igs] @m1[igd] @m1[igcs] @m1[igcd] @m1[igb] @m1[igidl] @m1[igisl] @m1[isub] @m1[ibd] @m1[ibs]
destroy all
altermod pmos vth0=-4.374792814e-01
altermod pmos toxe=9.852431236e-10
altermod pmos ndep=5.270235318e+18
altermod pmos u0=6.230347486e-03
altermod pmos xj=5.128982989e-09
alter m1 w=6.270189529e-08
alter vd dc=2.428688951e-01
alter vg dc=1.072636811e+00
alter vs dc=8.541526538e-01
alter vb dc=1.072636811e+00
option temp=118.797902
op
let idx = 41
wrdata C:/Users/udhav/DVD-Project/work/comp_pmos_off_10.out idx i(Vd) i(Vg) i(Vs) i(Vb) @m1[id] @m1[igs] @m1[igd] @m1[igcs] @m1[igcd] @m1[igb] @m1[igidl] @m1[igisl] @m1[isub] @m1[ibd] @m1[ibs]
destroy all
altermod pmos vth0=-4.096737336e-01
altermod pmos toxe=1.099003274e-09
altermod pmos ndep=5.164650775e+18
altermod pmos u0=6.514398435e-03
altermod pmos xj=5.071184545e-09
alter m1 w=9.831488245e-08
alter vd dc=6.625565632e-01
alter vg dc=9.813941725e-01
alter vs dc=5.457719269e-01
alter vb dc=9.813941725e-01
option temp=-6.765732
op
let idx = 42
wrdata C:/Users/udhav/DVD-Project/work/comp_pmos_off_10.out idx i(Vd) i(Vg) i(Vs) i(Vb) @m1[id] @m1[igs] @m1[igd] @m1[igcs] @m1[igcd] @m1[igb] @m1[igidl] @m1[igisl] @m1[isub] @m1[ibd] @m1[ibs]
destroy all
altermod pmos vth0=-4.101853568e-01
altermod pmos toxe=9.397052281e-10
altermod pmos ndep=5.049437273e+18
altermod pmos u0=6.303409300e-03
altermod pmos xj=4.581143965e-09
alter m1 w=5.304371657e-08
alter vd dc=1.415641663e-01
alter vg dc=1.089521011e+00
alter vs dc=1.001710588e-01
alter vb dc=1.089521011e+00
option temp=35.730806
op
let idx = 43
wrdata C:/Users/udhav/DVD-Project/work/comp_pmos_off_10.out idx i(Vd) i(Vg) i(Vs) i(Vb) @m1[id] @m1[igs] @m1[igd] @m1[igcs] @m1[igcd] @m1[igb] @m1[igidl] @m1[igisl] @m1[isub] @m1[ibd] @m1[ibs]
destroy all
altermod pmos vth0=-3.995466102e-01
altermod pmos toxe=1.032145516e-09
altermod pmos ndep=5.543866658e+18
altermod pmos u0=5.757491529e-03
altermod pmos xj=5.283579337e-09
alter m1 w=5.004050504e-08
alter vd dc=5.202534367e-01
alter vg dc=9.625937905e-01
alter vs dc=2.226040745e-01
alter vb dc=9.625937905e-01
option temp=92.813845
op
let idx = 44
wrdata C:/Users/udhav/DVD-Project/work/comp_pmos_off_10.out idx i(Vd) i(Vg) i(Vs) i(Vb) @m1[id] @m1[igs] @m1[igd] @m1[igcs] @m1[igcd] @m1[igb] @m1[igidl] @m1[igisl] @m1[isub] @m1[ibd] @m1[ibs]
destroy all
altermod pmos vth0=-4.318247046e-01
altermod pmos toxe=1.019286656e-09
altermod pmos ndep=5.921173933e+18
altermod pmos u0=6.380467709e-03
altermod pmos xj=5.307715545e-09
alter m1 w=4.457332094e-08
alter vd dc=4.880802218e-01
alter vg dc=9.633554134e-01
alter vs dc=5.474535891e-02
alter vb dc=9.633554134e-01
option temp=44.603509
op
let idx = 45
wrdata C:/Users/udhav/DVD-Project/work/comp_pmos_off_10.out idx i(Vd) i(Vg) i(Vs) i(Vb) @m1[id] @m1[igs] @m1[igd] @m1[igcs] @m1[igcd] @m1[igb] @m1[igidl] @m1[igisl] @m1[isub] @m1[ibd] @m1[ibs]
destroy all
altermod pmos vth0=-4.702118111e-01
altermod pmos toxe=9.674034580e-10
altermod pmos ndep=5.862321668e+18
altermod pmos u0=5.630649511e-03
altermod pmos xj=5.210044097e-09
alter m1 w=4.172144966e-08
alter vd dc=2.984170000e-01
alter vg dc=9.320447850e-01
alter vs dc=4.902732645e-01
alter vb dc=9.320447850e-01
option temp=42.504350
op
let idx = 46
wrdata C:/Users/udhav/DVD-Project/work/comp_pmos_off_10.out idx i(Vd) i(Vg) i(Vs) i(Vb) @m1[id] @m1[igs] @m1[igd] @m1[igcs] @m1[igcd] @m1[igb] @m1[igidl] @m1[igisl] @m1[isub] @m1[ibd] @m1[ibs]
destroy all
altermod pmos vth0=-4.345699820e-01
altermod pmos toxe=9.491669194e-10
altermod pmos ndep=5.960884786e+18
altermod pmos u0=6.013620028e-03
altermod pmos xj=4.844894791e-09
alter m1 w=1.251626122e-07
alter vd dc=9.986765090e-01
alter vg dc=1.042633394e+00
alter vs dc=2.552971604e-01
alter vb dc=1.042633394e+00
option temp=21.753616
op
let idx = 47
wrdata C:/Users/udhav/DVD-Project/work/comp_pmos_off_10.out idx i(Vd) i(Vg) i(Vs) i(Vb) @m1[id] @m1[igs] @m1[igd] @m1[igcs] @m1[igcd] @m1[igb] @m1[igidl] @m1[igisl] @m1[isub] @m1[ibd] @m1[ibs]
destroy all
altermod pmos vth0=-4.645266927e-01
altermod pmos toxe=1.038533816e-09
altermod pmos ndep=5.547705899e+18
altermod pmos u0=5.467132134e-03
altermod pmos xj=5.013954650e-09
alter m1 w=1.201967158e-07
alter vd dc=8.515519691e-01
alter vg dc=9.856640032e-01
alter vs dc=6.738346171e-01
alter vb dc=9.856640032e-01
option temp=110.777416
op
let idx = 48
wrdata C:/Users/udhav/DVD-Project/work/comp_pmos_off_10.out idx i(Vd) i(Vg) i(Vs) i(Vb) @m1[id] @m1[igs] @m1[igd] @m1[igcs] @m1[igcd] @m1[igb] @m1[igidl] @m1[igisl] @m1[isub] @m1[ibd] @m1[ibs]
destroy all
altermod pmos vth0=-4.154122088e-01
altermod pmos toxe=1.063107190e-09
altermod pmos ndep=6.015950580e+18
altermod pmos u0=5.741806079e-03
altermod pmos xj=4.735236717e-09
alter m1 w=1.264843155e-07
alter vd dc=6.497959305e-01
alter vg dc=9.264017825e-01
alter vs dc=3.160257715e-02
alter vb dc=9.264017825e-01
option temp=75.258951
op
let idx = 49
wrdata C:/Users/udhav/DVD-Project/work/comp_pmos_off_10.out idx i(Vd) i(Vg) i(Vs) i(Vb) @m1[id] @m1[igs] @m1[igd] @m1[igcs] @m1[igcd] @m1[igb] @m1[igidl] @m1[igisl] @m1[isub] @m1[ibd] @m1[ibs]
destroy all
altermod pmos vth0=-3.921951953e-01
altermod pmos toxe=9.019733043e-10
altermod pmos ndep=5.934016234e+18
altermod pmos u0=6.255402725e-03
altermod pmos xj=4.756251490e-09
alter m1 w=3.983102522e-08
alter vd dc=1.406435093e-01
alter vg dc=1.092917236e+00
alter vs dc=2.990402262e-01
alter vb dc=1.092917236e+00
option temp=75.667272
op
let idx = 50
wrdata C:/Users/udhav/DVD-Project/work/comp_pmos_off_10.out idx i(Vd) i(Vg) i(Vs) i(Vb) @m1[id] @m1[igs] @m1[igd] @m1[igcs] @m1[igcd] @m1[igb] @m1[igidl] @m1[igisl] @m1[isub] @m1[ibd] @m1[ibs]
destroy all
altermod pmos vth0=-3.908806014e-01
altermod pmos toxe=9.575679266e-10
altermod pmos ndep=5.434835732e+18
altermod pmos u0=5.703050540e-03
altermod pmos xj=4.993664866e-09
alter m1 w=9.517434050e-08
alter vd dc=5.640010132e-02
alter vg dc=1.095594659e+00
alter vs dc=9.235098530e-01
alter vb dc=1.095594659e+00
option temp=-5.736336
op
let idx = 51
wrdata C:/Users/udhav/DVD-Project/work/comp_pmos_off_10.out idx i(Vd) i(Vg) i(Vs) i(Vb) @m1[id] @m1[igs] @m1[igd] @m1[igcs] @m1[igcd] @m1[igb] @m1[igidl] @m1[igisl] @m1[isub] @m1[ibd] @m1[ibs]
destroy all
altermod pmos vth0=-4.299442836e-01
altermod pmos toxe=1.021441811e-09
altermod pmos ndep=6.029749616e+18
altermod pmos u0=6.116787113e-03
altermod pmos xj=4.737554690e-09
alter m1 w=1.139598036e-07
alter vd dc=5.440288364e-01
alter vg dc=9.398258279e-01
alter vs dc=4.107961742e-01
alter vb dc=9.398258279e-01
option temp=-34.988750
op
let idx = 52
wrdata C:/Users/udhav/DVD-Project/work/comp_pmos_off_10.out idx i(Vd) i(Vg) i(Vs) i(Vb) @m1[id] @m1[igs] @m1[igd] @m1[igcs] @m1[igcd] @m1[igb] @m1[igidl] @m1[igisl] @m1[isub] @m1[ibd] @m1[ibs]
destroy all
altermod pmos vth0=-4.723850979e-01
altermod pmos toxe=9.945935365e-10
altermod pmos ndep=5.279737335e+18
altermod pmos u0=5.676421586e-03
altermod pmos xj=4.515243176e-09
alter m1 w=1.146796057e-07
alter vd dc=1.608978006e-01
alter vg dc=9.936585979e-01
alter vs dc=1.787395032e-02
alter vb dc=9.936585979e-01
option temp=-17.601457
op
let idx = 53
wrdata C:/Users/udhav/DVD-Project/work/comp_pmos_off_10.out idx i(Vd) i(Vg) i(Vs) i(Vb) @m1[id] @m1[igs] @m1[igd] @m1[igcs] @m1[igcd] @m1[igb] @m1[igidl] @m1[igisl] @m1[isub] @m1[ibd] @m1[ibs]
destroy all
altermod pmos vth0=-4.501839664e-01
altermod pmos toxe=9.762465774e-10
altermod pmos ndep=5.014816542e+18
altermod pmos u0=6.211749492e-03
altermod pmos xj=4.991240722e-09
alter m1 w=7.514907125e-08
alter vd dc=2.545874685e-01
alter vg dc=1.057666457e+00
alter vs dc=7.751201772e-01
alter vb dc=1.057666457e+00
option temp=-39.764206
op
let idx = 54
wrdata C:/Users/udhav/DVD-Project/work/comp_pmos_off_10.out idx i(Vd) i(Vg) i(Vs) i(Vb) @m1[id] @m1[igs] @m1[igd] @m1[igcs] @m1[igcd] @m1[igb] @m1[igidl] @m1[igisl] @m1[isub] @m1[ibd] @m1[ibs]
destroy all
altermod pmos vth0=-4.437229697e-01
altermod pmos toxe=1.027809901e-09
altermod pmos ndep=5.808013435e+18
altermod pmos u0=6.108417455e-03
altermod pmos xj=4.917924182e-09
alter m1 w=7.025905762e-08
alter vd dc=7.978214517e-01
alter vg dc=9.861478120e-01
alter vs dc=5.227350540e-01
alter vb dc=9.861478120e-01
option temp=-11.158116
op
let idx = 55
wrdata C:/Users/udhav/DVD-Project/work/comp_pmos_off_10.out idx i(Vd) i(Vg) i(Vs) i(Vb) @m1[id] @m1[igs] @m1[igd] @m1[igcs] @m1[igcd] @m1[igb] @m1[igidl] @m1[igisl] @m1[isub] @m1[ibd] @m1[ibs]
destroy all
altermod pmos vth0=-3.906268883e-01
altermod pmos toxe=9.249814728e-10
altermod pmos ndep=4.973275462e+18
altermod pmos u0=5.849781946e-03
altermod pmos xj=5.172669444e-09
alter m1 w=1.091029661e-07
alter vd dc=8.256322699e-01
alter vg dc=9.075945389e-01
alter vs dc=1.285039312e-01
alter vb dc=9.075945389e-01
option temp=54.800367
op
let idx = 56
wrdata C:/Users/udhav/DVD-Project/work/comp_pmos_off_10.out idx i(Vd) i(Vg) i(Vs) i(Vb) @m1[id] @m1[igs] @m1[igd] @m1[igcs] @m1[igcd] @m1[igb] @m1[igidl] @m1[igisl] @m1[isub] @m1[ibd] @m1[ibs]
destroy all
altermod pmos vth0=-4.437630334e-01
altermod pmos toxe=9.651521423e-10
altermod pmos ndep=5.132659009e+18
altermod pmos u0=5.436258085e-03
altermod pmos xj=5.062638191e-09
alter m1 w=6.059122725e-08
alter vd dc=4.666346412e-02
alter vg dc=1.077917723e+00
alter vs dc=6.693724159e-01
alter vb dc=1.077917723e+00
option temp=121.352838
op
let idx = 57
wrdata C:/Users/udhav/DVD-Project/work/comp_pmos_off_10.out idx i(Vd) i(Vg) i(Vs) i(Vb) @m1[id] @m1[igs] @m1[igd] @m1[igcs] @m1[igcd] @m1[igb] @m1[igidl] @m1[igisl] @m1[isub] @m1[ibd] @m1[ibs]
destroy all
altermod pmos vth0=-4.529203824e-01
altermod pmos toxe=1.032900406e-09
altermod pmos ndep=5.323639908e+18
altermod pmos u0=6.015993133e-03
altermod pmos xj=4.984389987e-09
alter m1 w=2.952392003e-08
alter vd dc=9.052581395e-01
alter vg dc=1.030056500e+00
alter vs dc=6.273784385e-01
alter vb dc=1.030056500e+00
option temp=23.022499
op
let idx = 58
wrdata C:/Users/udhav/DVD-Project/work/comp_pmos_off_10.out idx i(Vd) i(Vg) i(Vs) i(Vb) @m1[id] @m1[igs] @m1[igd] @m1[igcs] @m1[igcd] @m1[igb] @m1[igidl] @m1[igisl] @m1[isub] @m1[ibd] @m1[ibs]
destroy all
altermod pmos vth0=-4.423410937e-01
altermod pmos toxe=9.853106114e-10
altermod pmos ndep=5.117825055e+18
altermod pmos u0=6.342397838e-03
altermod pmos xj=5.335199405e-09
alter m1 w=6.748848398e-08
alter vd dc=9.284995865e-02
alter vg dc=1.036672409e+00
alter vs dc=5.869423743e-01
alter vb dc=1.036672409e+00
option temp=-32.792883
op
let idx = 59
wrdata C:/Users/udhav/DVD-Project/work/comp_pmos_off_10.out idx i(Vd) i(Vg) i(Vs) i(Vb) @m1[id] @m1[igs] @m1[igd] @m1[igcs] @m1[igcd] @m1[igb] @m1[igidl] @m1[igisl] @m1[isub] @m1[ibd] @m1[ibs]
destroy all
altermod pmos vth0=-4.351663784e-01
altermod pmos toxe=1.016146618e-09
altermod pmos ndep=5.268005727e+18
altermod pmos u0=6.344067948e-03
altermod pmos xj=4.575461563e-09
alter m1 w=5.728767727e-08
alter vd dc=1.608963140e-02
alter vg dc=9.986456564e-01
alter vs dc=9.320727953e-01
alter vb dc=9.986456564e-01
option temp=-20.057743
op
let idx = 60
wrdata C:/Users/udhav/DVD-Project/work/comp_pmos_off_10.out idx i(Vd) i(Vg) i(Vs) i(Vb) @m1[id] @m1[igs] @m1[igd] @m1[igcs] @m1[igcd] @m1[igb] @m1[igidl] @m1[igisl] @m1[isub] @m1[ibd] @m1[ibs]
destroy all
altermod pmos vth0=-4.393518282e-01
altermod pmos toxe=9.561980101e-10
altermod pmos ndep=5.814218020e+18
altermod pmos u0=5.560039183e-03
altermod pmos xj=5.034106851e-09
alter m1 w=6.203444843e-08
alter vd dc=7.592601124e-01
alter vg dc=9.032210460e-01
alter vs dc=2.677142028e-01
alter vb dc=9.032210460e-01
option temp=38.541718
op
let idx = 61
wrdata C:/Users/udhav/DVD-Project/work/comp_pmos_off_10.out idx i(Vd) i(Vg) i(Vs) i(Vb) @m1[id] @m1[igs] @m1[igd] @m1[igcs] @m1[igcd] @m1[igb] @m1[igidl] @m1[igisl] @m1[isub] @m1[ibd] @m1[ibs]
destroy all
altermod pmos vth0=-4.512587050e-01
altermod pmos toxe=9.287690439e-10
altermod pmos ndep=5.523514753e+18
altermod pmos u0=5.915243969e-03
altermod pmos xj=5.347846682e-09
alter m1 w=1.229682529e-07
alter vd dc=2.304152714e-02
alter vg dc=1.020339982e+00
alter vs dc=2.680757840e-01
alter vb dc=1.020339982e+00
option temp=101.746520
op
let idx = 62
wrdata C:/Users/udhav/DVD-Project/work/comp_pmos_off_10.out idx i(Vd) i(Vg) i(Vs) i(Vb) @m1[id] @m1[igs] @m1[igd] @m1[igcs] @m1[igcd] @m1[igb] @m1[igidl] @m1[igisl] @m1[isub] @m1[ibd] @m1[ibs]
destroy all
altermod pmos vth0=-4.313324473e-01
altermod pmos toxe=9.978619327e-10
altermod pmos ndep=5.860283016e+18
altermod pmos u0=6.526845074e-03
altermod pmos xj=5.170570912e-09
alter m1 w=8.623043482e-08
alter vd dc=9.793159415e-01
alter vg dc=1.079714054e+00
alter vs dc=1.073173278e+00
alter vb dc=1.079714054e+00
option temp=8.094480
op
let idx = 63
wrdata C:/Users/udhav/DVD-Project/work/comp_pmos_off_10.out idx i(Vd) i(Vg) i(Vs) i(Vb) @m1[id] @m1[igs] @m1[igd] @m1[igcs] @m1[igcd] @m1[igb] @m1[igidl] @m1[igisl] @m1[isub] @m1[ibd] @m1[ibs]
destroy all
altermod pmos vth0=-4.025898674e-01
altermod pmos toxe=9.157537996e-10
altermod pmos ndep=5.927363049e+18
altermod pmos u0=5.913814719e-03
altermod pmos xj=4.550377143e-09
alter m1 w=4.244427041e-08
alter vd dc=4.575275930e-01
alter vg dc=9.978368489e-01
alter vs dc=9.616705709e-01
alter vb dc=9.978368489e-01
option temp=-35.255118
op
let idx = 64
wrdata C:/Users/udhav/DVD-Project/work/comp_pmos_off_10.out idx i(Vd) i(Vg) i(Vs) i(Vb) @m1[id] @m1[igs] @m1[igd] @m1[igcs] @m1[igcd] @m1[igb] @m1[igidl] @m1[igisl] @m1[isub] @m1[ibd] @m1[ibs]
destroy all
altermod pmos vth0=-4.605090372e-01
altermod pmos toxe=1.037423719e-09
altermod pmos ndep=5.192176590e+18
altermod pmos u0=6.454005406e-03
altermod pmos xj=4.624170234e-09
alter m1 w=1.269208836e-07
alter vd dc=4.741513492e-01
alter vg dc=9.554862397e-01
alter vs dc=5.770454146e-02
alter vb dc=9.554862397e-01
option temp=97.330918
op
let idx = 65
wrdata C:/Users/udhav/DVD-Project/work/comp_pmos_off_10.out idx i(Vd) i(Vg) i(Vs) i(Vb) @m1[id] @m1[igs] @m1[igd] @m1[igcs] @m1[igcd] @m1[igb] @m1[igidl] @m1[igisl] @m1[isub] @m1[ibd] @m1[ibs]
destroy all
altermod pmos vth0=-4.299596390e-01
altermod pmos toxe=9.639667398e-10
altermod pmos ndep=5.323519715e+18
altermod pmos u0=6.170798574e-03
altermod pmos xj=5.108005196e-09
alter m1 w=9.911680672e-08
alter vd dc=5.280197225e-01
alter vg dc=9.034351501e-01
alter vs dc=4.089782822e-02
alter vb dc=9.034351501e-01
option temp=-32.150872
op
let idx = 66
wrdata C:/Users/udhav/DVD-Project/work/comp_pmos_off_10.out idx i(Vd) i(Vg) i(Vs) i(Vb) @m1[id] @m1[igs] @m1[igd] @m1[igcs] @m1[igcd] @m1[igb] @m1[igidl] @m1[igisl] @m1[isub] @m1[ibd] @m1[ibs]
destroy all
altermod pmos vth0=-4.675800345e-01
altermod pmos toxe=9.487100068e-10
altermod pmos ndep=5.172397235e+18
altermod pmos u0=5.828613320e-03
altermod pmos xj=4.571766840e-09
alter m1 w=4.736460159e-08
alter vd dc=4.196103358e-02
alter vg dc=1.063962434e+00
alter vs dc=8.014562635e-01
alter vb dc=1.063962434e+00
option temp=78.047348
op
let idx = 67
wrdata C:/Users/udhav/DVD-Project/work/comp_pmos_off_10.out idx i(Vd) i(Vg) i(Vs) i(Vb) @m1[id] @m1[igs] @m1[igd] @m1[igcs] @m1[igcd] @m1[igb] @m1[igidl] @m1[igisl] @m1[isub] @m1[ibd] @m1[ibs]
destroy all
altermod pmos vth0=-4.150358791e-01
altermod pmos toxe=1.047113945e-09
altermod pmos ndep=5.300494287e+18
altermod pmos u0=6.339987296e-03
altermod pmos xj=5.469597479e-09
alter m1 w=1.002219222e-07
alter vd dc=5.296149920e-02
alter vg dc=9.129735193e-01
alter vs dc=2.722091646e-01
alter vb dc=9.129735193e-01
option temp=92.609979
op
let idx = 68
wrdata C:/Users/udhav/DVD-Project/work/comp_pmos_off_10.out idx i(Vd) i(Vg) i(Vs) i(Vb) @m1[id] @m1[igs] @m1[igd] @m1[igcs] @m1[igcd] @m1[igb] @m1[igidl] @m1[igisl] @m1[isub] @m1[ibd] @m1[ibs]
destroy all
altermod pmos vth0=-4.664969492e-01
altermod pmos toxe=9.246553847e-10
altermod pmos ndep=5.824546924e+18
altermod pmos u0=5.691493092e-03
altermod pmos xj=5.302940659e-09
alter m1 w=9.278420194e-08
alter vd dc=9.297163891e-01
alter vg dc=9.758330959e-01
alter vs dc=1.104919882e-01
alter vb dc=9.758330959e-01
option temp=-39.071766
op
let idx = 69
wrdata C:/Users/udhav/DVD-Project/work/comp_pmos_off_10.out idx i(Vd) i(Vg) i(Vs) i(Vb) @m1[id] @m1[igs] @m1[igd] @m1[igcs] @m1[igcd] @m1[igb] @m1[igidl] @m1[igisl] @m1[isub] @m1[ibd] @m1[ibs]
destroy all
altermod pmos vth0=-4.072154187e-01
altermod pmos toxe=9.775979709e-10
altermod pmos ndep=5.531609523e+18
altermod pmos u0=5.603984107e-03
altermod pmos xj=5.304644117e-09
alter m1 w=3.530247893e-08
alter vd dc=5.798649454e-02
alter vg dc=1.087538364e+00
alter vs dc=1.980317412e-01
alter vb dc=1.087538364e+00
option temp=80.520224
op
let idx = 70
wrdata C:/Users/udhav/DVD-Project/work/comp_pmos_off_10.out idx i(Vd) i(Vg) i(Vs) i(Vb) @m1[id] @m1[igs] @m1[igd] @m1[igcs] @m1[igcd] @m1[igb] @m1[igidl] @m1[igisl] @m1[isub] @m1[ibd] @m1[ibs]
destroy all
altermod pmos vth0=-4.235252319e-01
altermod pmos toxe=1.028228831e-09
altermod pmos ndep=5.280291275e+18
altermod pmos u0=6.011687529e-03
altermod pmos xj=5.450145331e-09
alter m1 w=8.139732799e-08
alter vd dc=5.401798689e-01
alter vg dc=1.007802991e+00
alter vs dc=8.581216192e-01
alter vb dc=1.007802991e+00
option temp=105.760186
op
let idx = 71
wrdata C:/Users/udhav/DVD-Project/work/comp_pmos_off_10.out idx i(Vd) i(Vg) i(Vs) i(Vb) @m1[id] @m1[igs] @m1[igd] @m1[igcs] @m1[igcd] @m1[igb] @m1[igidl] @m1[igisl] @m1[isub] @m1[ibd] @m1[ibs]
destroy all
altermod pmos vth0=-4.551576718e-01
altermod pmos toxe=1.004604944e-09
altermod pmos ndep=6.041700435e+18
altermod pmos u0=5.675581186e-03
altermod pmos xj=5.274278705e-09
alter m1 w=4.788982713e-08
alter vd dc=3.653601267e-01
alter vg dc=9.783553390e-01
alter vs dc=7.529619025e-01
alter vb dc=9.783553390e-01
option temp=46.335994
op
let idx = 72
wrdata C:/Users/udhav/DVD-Project/work/comp_pmos_off_10.out idx i(Vd) i(Vg) i(Vs) i(Vb) @m1[id] @m1[igs] @m1[igd] @m1[igcs] @m1[igcd] @m1[igb] @m1[igidl] @m1[igisl] @m1[isub] @m1[ibd] @m1[ibs]
destroy all
altermod pmos vth0=-4.170584241e-01
altermod pmos toxe=9.895197245e-10
altermod pmos ndep=4.956834568e+18
altermod pmos u0=6.072155983e-03
altermod pmos xj=5.056181081e-09
alter m1 w=9.970979695e-08
alter vd dc=7.404797214e-01
alter vg dc=9.265754909e-01
alter vs dc=3.382884621e-01
alter vb dc=9.265754909e-01
option temp=71.752576
op
let idx = 73
wrdata C:/Users/udhav/DVD-Project/work/comp_pmos_off_10.out idx i(Vd) i(Vg) i(Vs) i(Vb) @m1[id] @m1[igs] @m1[igd] @m1[igcs] @m1[igcd] @m1[igb] @m1[igidl] @m1[igisl] @m1[isub] @m1[ibd] @m1[ibs]
destroy all
altermod pmos vth0=-4.266236865e-01
altermod pmos toxe=1.065631185e-09
altermod pmos ndep=5.721845022e+18
altermod pmos u0=5.665996734e-03
altermod pmos xj=4.929530681e-09
alter m1 w=4.301631996e-08
alter vd dc=8.592285289e-01
alter vg dc=9.487263333e-01
alter vs dc=4.981752942e-01
alter vb dc=9.487263333e-01
option temp=-16.060477
op
let idx = 74
wrdata C:/Users/udhav/DVD-Project/work/comp_pmos_off_10.out idx i(Vd) i(Vg) i(Vs) i(Vb) @m1[id] @m1[igs] @m1[igd] @m1[igcs] @m1[igcd] @m1[igb] @m1[igidl] @m1[igisl] @m1[isub] @m1[ibd] @m1[ibs]
destroy all
altermod pmos vth0=-3.889798950e-01
altermod pmos toxe=1.094590694e-09
altermod pmos ndep=5.218565076e+18
altermod pmos u0=6.431310773e-03
altermod pmos xj=5.366255031e-09
alter m1 w=3.605751809e-08
alter vd dc=7.837415861e-01
alter vg dc=9.254402077e-01
alter vs dc=8.474362040e-01
alter vb dc=9.254402077e-01
option temp=-16.839413
op
let idx = 75
wrdata C:/Users/udhav/DVD-Project/work/comp_pmos_off_10.out idx i(Vd) i(Vg) i(Vs) i(Vb) @m1[id] @m1[igs] @m1[igd] @m1[igcs] @m1[igcd] @m1[igb] @m1[igidl] @m1[igisl] @m1[isub] @m1[ibd] @m1[ibs]
destroy all
altermod pmos vth0=-4.076185832e-01
altermod pmos toxe=1.046437780e-09
altermod pmos ndep=5.868029598e+18
altermod pmos u0=6.359358968e-03
altermod pmos xj=4.809564337e-09
alter m1 w=7.501506811e-08
alter vd dc=6.712077890e-01
alter vg dc=1.080012835e+00
alter vs dc=5.894632679e-01
alter vb dc=1.080012835e+00
option temp=74.923136
op
let idx = 76
wrdata C:/Users/udhav/DVD-Project/work/comp_pmos_off_10.out idx i(Vd) i(Vg) i(Vs) i(Vb) @m1[id] @m1[igs] @m1[igd] @m1[igcs] @m1[igcd] @m1[igb] @m1[igidl] @m1[igisl] @m1[isub] @m1[ibd] @m1[ibs]
destroy all
altermod pmos vth0=-4.307504645e-01
altermod pmos toxe=1.043780547e-09
altermod pmos ndep=5.606336496e+18
altermod pmos u0=6.413273002e-03
altermod pmos xj=4.663897891e-09
alter m1 w=1.194038257e-07
alter vd dc=1.522251251e-01
alter vg dc=9.896163168e-01
alter vs dc=2.375841196e-01
alter vb dc=9.896163168e-01
option temp=-38.991551
op
let idx = 77
wrdata C:/Users/udhav/DVD-Project/work/comp_pmos_off_10.out idx i(Vd) i(Vg) i(Vs) i(Vb) @m1[id] @m1[igs] @m1[igd] @m1[igcs] @m1[igcd] @m1[igb] @m1[igidl] @m1[igisl] @m1[isub] @m1[ibd] @m1[ibs]
destroy all
altermod pmos vth0=-4.354027160e-01
altermod pmos toxe=1.090789932e-09
altermod pmos ndep=5.821985747e+18
altermod pmos u0=5.964356012e-03
altermod pmos xj=4.785054996e-09
alter m1 w=1.799501793e-08
alter vd dc=3.593235442e-01
alter vg dc=9.611217299e-01
alter vs dc=8.283017842e-01
alter vb dc=9.611217299e-01
option temp=83.428988
op
let idx = 78
wrdata C:/Users/udhav/DVD-Project/work/comp_pmos_off_10.out idx i(Vd) i(Vg) i(Vs) i(Vb) @m1[id] @m1[igs] @m1[igd] @m1[igcs] @m1[igcd] @m1[igb] @m1[igidl] @m1[igisl] @m1[isub] @m1[ibd] @m1[ibs]
destroy all
altermod pmos vth0=-4.250376576e-01
altermod pmos toxe=9.343569535e-10
altermod pmos ndep=5.312802038e+18
altermod pmos u0=5.427270597e-03
altermod pmos xj=5.297646722e-09
alter m1 w=1.160131451e-07
alter vd dc=1.000999922e-02
alter vg dc=1.025041498e+00
alter vs dc=5.463650568e-01
alter vb dc=1.025041498e+00
option temp=63.771296
op
let idx = 79
wrdata C:/Users/udhav/DVD-Project/work/comp_pmos_off_10.out idx i(Vd) i(Vg) i(Vs) i(Vb) @m1[id] @m1[igs] @m1[igd] @m1[igcs] @m1[igcd] @m1[igb] @m1[igidl] @m1[igisl] @m1[isub] @m1[ibd] @m1[ibs]
destroy all
altermod pmos vth0=-4.540102676e-01
altermod pmos toxe=1.011020649e-09
altermod pmos ndep=5.805443541e+18
altermod pmos u0=6.487591647e-03
altermod pmos xj=5.051281720e-09
alter m1 w=1.279381764e-07
alter vd dc=7.683591165e-01
alter vg dc=1.075943807e+00
alter vs dc=2.525331639e-01
alter vb dc=1.075943807e+00
option temp=39.719734
op
let idx = 80
wrdata C:/Users/udhav/DVD-Project/work/comp_pmos_off_10.out idx i(Vd) i(Vg) i(Vs) i(Vb) @m1[id] @m1[igs] @m1[igd] @m1[igcs] @m1[igcd] @m1[igb] @m1[igidl] @m1[igisl] @m1[isub] @m1[ibd] @m1[ibs]
destroy all
altermod pmos vth0=-4.229054781e-01
altermod pmos toxe=9.053148926e-10
altermod pmos ndep=5.349792985e+18
altermod pmos u0=6.151970257e-03
altermod pmos xj=4.870335954e-09
alter m1 w=1.224464702e-07
alter vd dc=3.539528217e-01
alter vg dc=9.151788827e-01
alter vs dc=2.058061773e-01
alter vb dc=9.151788827e-01
option temp=22.467499
op
let idx = 81
wrdata C:/Users/udhav/DVD-Project/work/comp_pmos_off_10.out idx i(Vd) i(Vg) i(Vs) i(Vb) @m1[id] @m1[igs] @m1[igd] @m1[igcs] @m1[igcd] @m1[igb] @m1[igidl] @m1[igisl] @m1[isub] @m1[ibd] @m1[ibs]
destroy all
altermod pmos vth0=-4.549927617e-01
altermod pmos toxe=9.334890712e-10
altermod pmos ndep=6.011721067e+18
altermod pmos u0=6.014116529e-03
altermod pmos xj=5.142811043e-09
alter m1 w=1.047476556e-07
alter vd dc=6.492183295e-01
alter vg dc=9.947660073e-01
alter vs dc=5.683958259e-01
alter vb dc=9.947660073e-01
option temp=114.364692
op
let idx = 82
wrdata C:/Users/udhav/DVD-Project/work/comp_pmos_off_10.out idx i(Vd) i(Vg) i(Vs) i(Vb) @m1[id] @m1[igs] @m1[igd] @m1[igcs] @m1[igcd] @m1[igb] @m1[igidl] @m1[igisl] @m1[isub] @m1[ibd] @m1[ibs]
destroy all
altermod pmos vth0=-4.079354120e-01
altermod pmos toxe=1.072961866e-09
altermod pmos ndep=4.974145994e+18
altermod pmos u0=5.672099798e-03
altermod pmos xj=5.107588578e-09
alter m1 w=7.757175822e-08
alter vd dc=5.478541413e-01
alter vg dc=9.856421243e-01
alter vs dc=3.010028286e-01
alter vb dc=9.856421243e-01
option temp=67.854440
op
let idx = 83
wrdata C:/Users/udhav/DVD-Project/work/comp_pmos_off_10.out idx i(Vd) i(Vg) i(Vs) i(Vb) @m1[id] @m1[igs] @m1[igd] @m1[igcs] @m1[igcd] @m1[igb] @m1[igidl] @m1[igisl] @m1[isub] @m1[ibd] @m1[ibs]
destroy all
altermod pmos vth0=-3.885726329e-01
altermod pmos toxe=9.862913271e-10
altermod pmos ndep=5.195471858e+18
altermod pmos u0=6.216701187e-03
altermod pmos xj=4.814763064e-09
alter m1 w=1.246720222e-07
alter vd dc=8.057544794e-02
alter vg dc=1.030832282e+00
alter vs dc=3.521377004e-01
alter vb dc=1.030832282e+00
option temp=82.063259
op
let idx = 84
wrdata C:/Users/udhav/DVD-Project/work/comp_pmos_off_10.out idx i(Vd) i(Vg) i(Vs) i(Vb) @m1[id] @m1[igs] @m1[igd] @m1[igcs] @m1[igcd] @m1[igb] @m1[igidl] @m1[igisl] @m1[isub] @m1[ibd] @m1[ibs]
destroy all
altermod pmos vth0=-3.962569929e-01
altermod pmos toxe=9.678731261e-10
altermod pmos ndep=5.684619909e+18
altermod pmos u0=5.781664228e-03
altermod pmos xj=4.571104838e-09
alter m1 w=1.116969173e-07
alter vd dc=7.287395672e-01
alter vg dc=9.250959643e-01
alter vs dc=9.779300608e-02
alter vb dc=9.250959643e-01
option temp=49.101787
op
let idx = 85
wrdata C:/Users/udhav/DVD-Project/work/comp_pmos_off_10.out idx i(Vd) i(Vg) i(Vs) i(Vb) @m1[id] @m1[igs] @m1[igd] @m1[igcs] @m1[igcd] @m1[igb] @m1[igidl] @m1[igisl] @m1[isub] @m1[ibd] @m1[ibs]
destroy all
altermod pmos vth0=-4.673225116e-01
altermod pmos toxe=1.020552416e-09
altermod pmos ndep=6.020264517e+18
altermod pmos u0=6.587892153e-03
altermod pmos xj=4.782584216e-09
alter m1 w=3.670721863e-08
alter vd dc=1.035755974e+00
alter vg dc=1.093958465e+00
alter vs dc=3.845609301e-01
alter vb dc=1.093958465e+00
option temp=-33.323150
op
let idx = 86
wrdata C:/Users/udhav/DVD-Project/work/comp_pmos_off_10.out idx i(Vd) i(Vg) i(Vs) i(Vb) @m1[id] @m1[igs] @m1[igd] @m1[igcs] @m1[igcd] @m1[igb] @m1[igidl] @m1[igisl] @m1[isub] @m1[ibd] @m1[ibs]
destroy all
altermod pmos vth0=-4.442756842e-01
altermod pmos toxe=1.085682001e-09
altermod pmos ndep=5.647045372e+18
altermod pmos u0=5.920239269e-03
altermod pmos xj=5.126112313e-09
alter m1 w=1.076806894e-07
alter vd dc=2.446951466e-01
alter vg dc=9.127356109e-01
alter vs dc=7.794391873e-01
alter vb dc=9.127356109e-01
option temp=39.169299
op
let idx = 87
wrdata C:/Users/udhav/DVD-Project/work/comp_pmos_off_10.out idx i(Vd) i(Vg) i(Vs) i(Vb) @m1[id] @m1[igs] @m1[igd] @m1[igcs] @m1[igcd] @m1[igb] @m1[igidl] @m1[igisl] @m1[isub] @m1[ibd] @m1[ibs]
destroy all
altermod pmos vth0=-4.470741258e-01
altermod pmos toxe=1.030975174e-09
altermod pmos ndep=5.780550373e+18
altermod pmos u0=5.739769873e-03
altermod pmos xj=4.694872328e-09
alter m1 w=1.230619997e-07
alter vd dc=5.104614773e-01
alter vg dc=9.372091052e-01
alter vs dc=2.747711928e-01
alter vb dc=9.372091052e-01
option temp=101.375327
op
let idx = 88
wrdata C:/Users/udhav/DVD-Project/work/comp_pmos_off_10.out idx i(Vd) i(Vg) i(Vs) i(Vb) @m1[id] @m1[igs] @m1[igd] @m1[igcs] @m1[igcd] @m1[igb] @m1[igidl] @m1[igisl] @m1[isub] @m1[ibd] @m1[ibs]
destroy all
altermod pmos vth0=-4.557096474e-01
altermod pmos toxe=1.038220642e-09
altermod pmos ndep=5.793196721e+18
altermod pmos u0=5.795330797e-03
altermod pmos xj=4.554818337e-09
alter m1 w=4.626006822e-08
alter vd dc=1.051789688e+00
alter vg dc=1.065474773e+00
alter vs dc=9.975054546e-01
alter vb dc=1.065474773e+00
option temp=87.887820
op
let idx = 89
wrdata C:/Users/udhav/DVD-Project/work/comp_pmos_off_10.out idx i(Vd) i(Vg) i(Vs) i(Vb) @m1[id] @m1[igs] @m1[igd] @m1[igcs] @m1[igcd] @m1[igb] @m1[igidl] @m1[igisl] @m1[isub] @m1[ibd] @m1[ibs]
destroy all
altermod pmos vth0=-4.093173677e-01
altermod pmos toxe=1.081457657e-09
altermod pmos ndep=5.733693537e+18
altermod pmos u0=6.373049973e-03
altermod pmos xj=5.453113749e-09
alter m1 w=4.005667606e-08
alter vd dc=2.891813430e-01
alter vg dc=9.556153814e-01
alter vs dc=6.513608455e-01
alter vb dc=9.556153814e-01
option temp=10.172923
op
let idx = 90
wrdata C:/Users/udhav/DVD-Project/work/comp_pmos_off_10.out idx i(Vd) i(Vg) i(Vs) i(Vb) @m1[id] @m1[igs] @m1[igd] @m1[igcs] @m1[igcd] @m1[igb] @m1[igidl] @m1[igisl] @m1[isub] @m1[ibd] @m1[ibs]
destroy all
altermod pmos vth0=-4.308022556e-01
altermod pmos toxe=1.035537448e-09
altermod pmos ndep=5.553554261e+18
altermod pmos u0=5.936431159e-03
altermod pmos xj=5.442088343e-09
alter m1 w=7.180003171e-08
alter vd dc=5.777800417e-01
alter vg dc=1.006356905e+00
alter vs dc=8.672009544e-01
alter vb dc=1.006356905e+00
option temp=110.625888
op
let idx = 91
wrdata C:/Users/udhav/DVD-Project/work/comp_pmos_off_10.out idx i(Vd) i(Vg) i(Vs) i(Vb) @m1[id] @m1[igs] @m1[igd] @m1[igcs] @m1[igcd] @m1[igb] @m1[igidl] @m1[igisl] @m1[isub] @m1[ibd] @m1[ibs]
destroy all
altermod pmos vth0=-4.553637164e-01
altermod pmos toxe=1.021154070e-09
altermod pmos ndep=4.962610937e+18
altermod pmos u0=6.142697478e-03
altermod pmos xj=5.206042937e-09
alter m1 w=5.536260623e-08
alter vd dc=2.556985675e-02
alter vg dc=9.987667714e-01
alter vs dc=1.340058365e-01
alter vb dc=9.987667714e-01
option temp=58.838718
op
let idx = 92
wrdata C:/Users/udhav/DVD-Project/work/comp_pmos_off_10.out idx i(Vd) i(Vg) i(Vs) i(Vb) @m1[id] @m1[igs] @m1[igd] @m1[igcs] @m1[igcd] @m1[igb] @m1[igidl] @m1[igisl] @m1[isub] @m1[ibd] @m1[ibs]
destroy all
altermod pmos vth0=-4.303382848e-01
altermod pmos toxe=9.197081316e-10
altermod pmos ndep=5.203249457e+18
altermod pmos u0=5.448039432e-03
altermod pmos xj=5.492552087e-09
alter m1 w=5.264031458e-08
alter vd dc=3.689744841e-01
alter vg dc=9.286942835e-01
alter vs dc=1.976890553e-01
alter vb dc=9.286942835e-01
option temp=68.118100
op
let idx = 93
wrdata C:/Users/udhav/DVD-Project/work/comp_pmos_off_10.out idx i(Vd) i(Vg) i(Vs) i(Vb) @m1[id] @m1[igs] @m1[igd] @m1[igcs] @m1[igcd] @m1[igb] @m1[igidl] @m1[igisl] @m1[isub] @m1[ibd] @m1[ibs]
destroy all
altermod pmos vth0=-4.184839406e-01
altermod pmos toxe=1.025940795e-09
altermod pmos ndep=4.977665104e+18
altermod pmos u0=6.099155506e-03
altermod pmos xj=5.391109575e-09
alter m1 w=1.069601921e-07
alter vd dc=3.824904552e-01
alter vg dc=1.025121387e+00
alter vs dc=3.382275595e-01
alter vb dc=1.025121387e+00
option temp=-18.842484
op
let idx = 94
wrdata C:/Users/udhav/DVD-Project/work/comp_pmos_off_10.out idx i(Vd) i(Vg) i(Vs) i(Vb) @m1[id] @m1[igs] @m1[igd] @m1[igcs] @m1[igcd] @m1[igb] @m1[igidl] @m1[igisl] @m1[isub] @m1[ibd] @m1[ibs]
destroy all
altermod pmos vth0=-4.417228914e-01
altermod pmos toxe=9.039978805e-10
altermod pmos ndep=5.774882050e+18
altermod pmos u0=6.483112204e-03
altermod pmos xj=5.489258686e-09
alter m1 w=1.867056406e-08
alter vd dc=6.566089988e-01
alter vg dc=1.015531946e+00
alter vs dc=4.240296594e-01
alter vb dc=1.015531946e+00
option temp=18.085124
op
let idx = 95
wrdata C:/Users/udhav/DVD-Project/work/comp_pmos_off_10.out idx i(Vd) i(Vg) i(Vs) i(Vb) @m1[id] @m1[igs] @m1[igd] @m1[igcs] @m1[igcd] @m1[igb] @m1[igidl] @m1[igisl] @m1[isub] @m1[ibd] @m1[ibs]
destroy all
altermod pmos vth0=-4.698205950e-01
altermod pmos toxe=1.081582769e-09
altermod pmos ndep=5.840362994e+18
altermod pmos u0=5.701573855e-03
altermod pmos xj=5.071221737e-09
alter m1 w=7.183619815e-08
alter vd dc=5.935011762e-01
alter vg dc=9.176005640e-01
alter vs dc=4.525895196e-01
alter vb dc=9.176005640e-01
option temp=27.945226
op
let idx = 96
wrdata C:/Users/udhav/DVD-Project/work/comp_pmos_off_10.out idx i(Vd) i(Vg) i(Vs) i(Vb) @m1[id] @m1[igs] @m1[igd] @m1[igcs] @m1[igcd] @m1[igb] @m1[igidl] @m1[igisl] @m1[isub] @m1[ibd] @m1[ibs]
destroy all
altermod pmos vth0=-4.639299186e-01
altermod pmos toxe=9.576105856e-10
altermod pmos ndep=5.584451694e+18
altermod pmos u0=6.120051634e-03
altermod pmos xj=4.767282259e-09
alter m1 w=4.761383846e-08
alter vd dc=9.225605584e-01
alter vg dc=1.003472209e+00
alter vs dc=3.633849637e-01
alter vb dc=1.003472209e+00
option temp=-5.665995
op
let idx = 97
wrdata C:/Users/udhav/DVD-Project/work/comp_pmos_off_10.out idx i(Vd) i(Vg) i(Vs) i(Vb) @m1[id] @m1[igs] @m1[igd] @m1[igcs] @m1[igcd] @m1[igb] @m1[igidl] @m1[igisl] @m1[isub] @m1[ibd] @m1[ibs]
destroy all
altermod pmos vth0=-4.236428205e-01
altermod pmos toxe=1.003391681e-09
altermod pmos ndep=5.716106303e+18
altermod pmos u0=6.303155360e-03
altermod pmos xj=4.670928388e-09
alter m1 w=2.346439408e-08
alter vd dc=2.901178934e-01
alter vg dc=1.083503439e+00
alter vs dc=3.870238528e-01
alter vb dc=1.083503439e+00
option temp=85.424806
op
let idx = 98
wrdata C:/Users/udhav/DVD-Project/work/comp_pmos_off_10.out idx i(Vd) i(Vg) i(Vs) i(Vb) @m1[id] @m1[igs] @m1[igd] @m1[igcs] @m1[igcd] @m1[igb] @m1[igidl] @m1[igisl] @m1[isub] @m1[ibd] @m1[ibs]
destroy all
altermod pmos vth0=-4.696388826e-01
altermod pmos toxe=9.087460305e-10
altermod pmos ndep=5.766917579e+18
altermod pmos u0=6.440640151e-03
altermod pmos xj=5.196041643e-09
alter m1 w=5.264086349e-08
alter vd dc=3.286804498e-01
alter vg dc=1.080784255e+00
alter vs dc=8.428403998e-01
alter vb dc=1.080784255e+00
option temp=97.004874
op
let idx = 99
wrdata C:/Users/udhav/DVD-Project/work/comp_pmos_off_10.out idx i(Vd) i(Vg) i(Vs) i(Vb) @m1[id] @m1[igs] @m1[igd] @m1[igcs] @m1[igcd] @m1[igb] @m1[igidl] @m1[igisl] @m1[isub] @m1[ibd] @m1[ibs]
destroy all
altermod pmos vth0=-4.465409077e-01
altermod pmos toxe=1.068379342e-09
altermod pmos ndep=5.313149338e+18
altermod pmos u0=6.461554900e-03
altermod pmos xj=5.490792787e-09
alter m1 w=7.154446590e-08
alter vd dc=4.047136965e-02
alter vg dc=1.018294702e+00
alter vs dc=8.371122384e-01
alter vb dc=1.018294702e+00
option temp=-15.951346
op
let idx = 100
wrdata C:/Users/udhav/DVD-Project/work/comp_pmos_off_10.out idx i(Vd) i(Vg) i(Vs) i(Vb) @m1[id] @m1[igs] @m1[igd] @m1[igcs] @m1[igcd] @m1[igb] @m1[igidl] @m1[igisl] @m1[isub] @m1[ibd] @m1[ibs]
destroy all
altermod pmos vth0=-4.079386705e-01
altermod pmos toxe=1.075558144e-09
altermod pmos ndep=5.502565622e+18
altermod pmos u0=6.214286385e-03
altermod pmos xj=4.716709082e-09
alter m1 w=7.864788486e-08
alter vd dc=6.963718493e-01
alter vg dc=9.662917997e-01
alter vs dc=6.332090017e-01
alter vb dc=9.662917997e-01
option temp=66.491732
op
let idx = 101
wrdata C:/Users/udhav/DVD-Project/work/comp_pmos_off_10.out idx i(Vd) i(Vg) i(Vs) i(Vb) @m1[id] @m1[igs] @m1[igd] @m1[igcs] @m1[igcd] @m1[igb] @m1[igidl] @m1[igisl] @m1[isub] @m1[ibd] @m1[ibs]
destroy all
altermod pmos vth0=-4.259990013e-01
altermod pmos toxe=9.248723887e-10
altermod pmos ndep=5.748842711e+18
altermod pmos u0=6.553356667e-03
altermod pmos xj=4.967838384e-09
alter m1 w=8.972749056e-08
alter vd dc=6.195089254e-01
alter vg dc=9.367654448e-01
alter vs dc=5.143051369e-01
alter vb dc=9.367654448e-01
option temp=36.687152
op
let idx = 102
wrdata C:/Users/udhav/DVD-Project/work/comp_pmos_off_10.out idx i(Vd) i(Vg) i(Vs) i(Vb) @m1[id] @m1[igs] @m1[igd] @m1[igcs] @m1[igcd] @m1[igb] @m1[igidl] @m1[igisl] @m1[isub] @m1[ibd] @m1[ibs]
destroy all
altermod pmos vth0=-4.604267011e-01
altermod pmos toxe=1.045613443e-09
altermod pmos ndep=5.698307068e+18
altermod pmos u0=6.367402732e-03
altermod pmos xj=4.863090444e-09
alter m1 w=1.251324805e-07
alter vd dc=2.831642125e-01
alter vg dc=9.952544406e-01
alter vs dc=8.695496420e-01
alter vb dc=9.952544406e-01
option temp=43.861611
op
let idx = 103
wrdata C:/Users/udhav/DVD-Project/work/comp_pmos_off_10.out idx i(Vd) i(Vg) i(Vs) i(Vb) @m1[id] @m1[igs] @m1[igd] @m1[igcs] @m1[igcd] @m1[igb] @m1[igidl] @m1[igisl] @m1[isub] @m1[ibd] @m1[ibs]
destroy all
altermod pmos vth0=-4.210766611e-01
altermod pmos toxe=1.054619036e-09
altermod pmos ndep=5.347189445e+18
altermod pmos u0=5.699419491e-03
altermod pmos xj=4.909892158e-09
alter m1 w=7.345368884e-08
alter vd dc=6.433387462e-01
alter vg dc=9.941299655e-01
alter vs dc=5.953835548e-02
alter vb dc=9.941299655e-01
option temp=-14.137678
op
let idx = 104
wrdata C:/Users/udhav/DVD-Project/work/comp_pmos_off_10.out idx i(Vd) i(Vg) i(Vs) i(Vb) @m1[id] @m1[igs] @m1[igd] @m1[igcs] @m1[igcd] @m1[igb] @m1[igidl] @m1[igisl] @m1[isub] @m1[ibd] @m1[ibs]
destroy all
altermod pmos vth0=-4.450617626e-01
altermod pmos toxe=9.416941419e-10
altermod pmos ndep=5.891471161e+18
altermod pmos u0=5.876161149e-03
altermod pmos xj=4.775058323e-09
alter m1 w=3.862055475e-08
alter vd dc=9.116508063e-01
alter vg dc=9.788356383e-01
alter vs dc=9.552621725e-01
alter vb dc=9.788356383e-01
option temp=55.196992
op
let idx = 105
wrdata C:/Users/udhav/DVD-Project/work/comp_pmos_off_10.out idx i(Vd) i(Vg) i(Vs) i(Vb) @m1[id] @m1[igs] @m1[igd] @m1[igcs] @m1[igcd] @m1[igb] @m1[igidl] @m1[igisl] @m1[isub] @m1[ibd] @m1[ibs]
destroy all
altermod pmos vth0=-4.491313441e-01
altermod pmos toxe=1.030900032e-09
altermod pmos ndep=5.801155517e+18
altermod pmos u0=6.022990773e-03
altermod pmos xj=4.757809405e-09
alter m1 w=7.024189315e-08
alter vd dc=6.181285540e-01
alter vg dc=9.960350800e-01
alter vs dc=8.779798106e-01
alter vb dc=9.960350800e-01
option temp=5.609714
op
let idx = 106
wrdata C:/Users/udhav/DVD-Project/work/comp_pmos_off_10.out idx i(Vd) i(Vg) i(Vs) i(Vb) @m1[id] @m1[igs] @m1[igd] @m1[igcs] @m1[igcd] @m1[igb] @m1[igidl] @m1[igisl] @m1[isub] @m1[ibd] @m1[ibs]
destroy all
altermod pmos vth0=-4.305949312e-01
altermod pmos toxe=1.054269245e-09
altermod pmos ndep=5.235032445e+18
altermod pmos u0=5.843519341e-03
altermod pmos xj=4.555805825e-09
alter m1 w=8.544897825e-08
alter vd dc=5.162467661e-01
alter vg dc=9.065838497e-01
alter vs dc=7.516521372e-01
alter vb dc=9.065838497e-01
option temp=-39.040269
op
let idx = 107
wrdata C:/Users/udhav/DVD-Project/work/comp_pmos_off_10.out idx i(Vd) i(Vg) i(Vs) i(Vb) @m1[id] @m1[igs] @m1[igd] @m1[igcs] @m1[igcd] @m1[igb] @m1[igidl] @m1[igisl] @m1[isub] @m1[ibd] @m1[ibs]
destroy all
altermod pmos vth0=-4.230511379e-01
altermod pmos toxe=1.085722730e-09
altermod pmos ndep=5.249222598e+18
altermod pmos u0=5.440965896e-03
altermod pmos xj=5.081173439e-09
alter m1 w=1.032261141e-07
alter vd dc=1.054393857e-01
alter vg dc=9.989538898e-01
alter vs dc=5.446420325e-01
alter vb dc=9.989538898e-01
option temp=62.214009
op
let idx = 108
wrdata C:/Users/udhav/DVD-Project/work/comp_pmos_off_10.out idx i(Vd) i(Vg) i(Vs) i(Vb) @m1[id] @m1[igs] @m1[igd] @m1[igcs] @m1[igcd] @m1[igb] @m1[igidl] @m1[igisl] @m1[isub] @m1[ibd] @m1[ibs]
destroy all
altermod pmos vth0=-4.492998971e-01
altermod pmos toxe=9.216738194e-10
altermod pmos ndep=5.818597981e+18
altermod pmos u0=5.874065405e-03
altermod pmos xj=5.075364118e-09
alter m1 w=2.751885630e-08
alter vd dc=7.547467049e-01
alter vg dc=9.298777340e-01
alter vs dc=4.631259747e-01
alter vb dc=9.298777340e-01
option temp=50.935715
op
let idx = 109
wrdata C:/Users/udhav/DVD-Project/work/comp_pmos_off_10.out idx i(Vd) i(Vg) i(Vs) i(Vb) @m1[id] @m1[igs] @m1[igd] @m1[igcs] @m1[igcd] @m1[igb] @m1[igidl] @m1[igisl] @m1[isub] @m1[ibd] @m1[ibs]
destroy all
altermod pmos vth0=-3.954075959e-01
altermod pmos toxe=9.247154394e-10
altermod pmos ndep=6.043524069e+18
altermod pmos u0=6.576590474e-03
altermod pmos xj=5.395786228e-09
alter m1 w=5.918961379e-08
alter vd dc=6.624125837e-01
alter vg dc=1.099857260e+00
alter vs dc=9.257856646e-01
alter vb dc=1.099857260e+00
option temp=42.345554
op
let idx = 110
wrdata C:/Users/udhav/DVD-Project/work/comp_pmos_off_10.out idx i(Vd) i(Vg) i(Vs) i(Vb) @m1[id] @m1[igs] @m1[igd] @m1[igcs] @m1[igcd] @m1[igb] @m1[igidl] @m1[igisl] @m1[isub] @m1[ibd] @m1[ibs]
destroy all
altermod pmos vth0=-3.884741023e-01
altermod pmos toxe=1.099577059e-09
altermod pmos ndep=5.114397107e+18
altermod pmos u0=5.719489053e-03
altermod pmos xj=5.274275063e-09
alter m1 w=9.969080982e-08
alter vd dc=6.375820305e-02
alter vg dc=1.049053699e+00
alter vs dc=7.906085197e-01
alter vb dc=1.049053699e+00
option temp=101.989061
op
let idx = 111
wrdata C:/Users/udhav/DVD-Project/work/comp_pmos_off_10.out idx i(Vd) i(Vg) i(Vs) i(Vb) @m1[id] @m1[igs] @m1[igd] @m1[igcs] @m1[igcd] @m1[igb] @m1[igidl] @m1[igisl] @m1[isub] @m1[ibd] @m1[ibs]
destroy all
altermod pmos vth0=-4.081654157e-01
altermod pmos toxe=9.353799467e-10
altermod pmos ndep=5.392772250e+18
altermod pmos u0=5.575863086e-03
altermod pmos xj=4.557082378e-09
alter m1 w=4.149168155e-08
alter vd dc=6.564831595e-01
alter vg dc=9.077932935e-01
alter vs dc=1.270221677e-01
alter vb dc=9.077932935e-01
option temp=73.827383
op
let idx = 112
wrdata C:/Users/udhav/DVD-Project/work/comp_pmos_off_10.out idx i(Vd) i(Vg) i(Vs) i(Vb) @m1[id] @m1[igs] @m1[igd] @m1[igcs] @m1[igcd] @m1[igb] @m1[igidl] @m1[igisl] @m1[isub] @m1[ibd] @m1[ibs]
destroy all
altermod pmos vth0=-4.222418164e-01
altermod pmos toxe=9.024457459e-10
altermod pmos ndep=5.903895770e+18
altermod pmos u0=5.429530974e-03
altermod pmos xj=4.537111437e-09
alter m1 w=1.228813271e-07
alter vd dc=1.055749018e-02
alter vg dc=9.870654851e-01
alter vs dc=5.074925789e-01
alter vb dc=9.870654851e-01
option temp=56.963857
op
let idx = 113
wrdata C:/Users/udhav/DVD-Project/work/comp_pmos_off_10.out idx i(Vd) i(Vg) i(Vs) i(Vb) @m1[id] @m1[igs] @m1[igd] @m1[igcs] @m1[igcd] @m1[igb] @m1[igidl] @m1[igisl] @m1[isub] @m1[ibd] @m1[ibs]
destroy all
altermod pmos vth0=-4.077149683e-01
altermod pmos toxe=9.277947982e-10
altermod pmos ndep=5.982521158e+18
altermod pmos u0=6.317574661e-03
altermod pmos xj=5.062205776e-09
alter m1 w=2.162563324e-08
alter vd dc=6.262754167e-01
alter vg dc=9.359916741e-01
alter vs dc=6.330028574e-01
alter vb dc=9.359916741e-01
option temp=-16.605498
op
let idx = 114
wrdata C:/Users/udhav/DVD-Project/work/comp_pmos_off_10.out idx i(Vd) i(Vg) i(Vs) i(Vb) @m1[id] @m1[igs] @m1[igd] @m1[igcs] @m1[igcd] @m1[igb] @m1[igidl] @m1[igisl] @m1[isub] @m1[ibd] @m1[ibs]
destroy all
altermod pmos vth0=-3.916011634e-01
altermod pmos toxe=1.060984050e-09
altermod pmos ndep=5.868899137e+18
altermod pmos u0=6.021267057e-03
altermod pmos xj=5.124105657e-09
alter m1 w=4.100542444e-08
alter vd dc=5.702272465e-01
alter vg dc=1.094960242e+00
alter vs dc=9.963632613e-01
alter vb dc=1.094960242e+00
option temp=-26.934431
op
let idx = 115
wrdata C:/Users/udhav/DVD-Project/work/comp_pmos_off_10.out idx i(Vd) i(Vg) i(Vs) i(Vb) @m1[id] @m1[igs] @m1[igd] @m1[igcs] @m1[igcd] @m1[igb] @m1[igidl] @m1[igisl] @m1[isub] @m1[ibd] @m1[ibs]
destroy all
altermod pmos vth0=-3.979162094e-01
altermod pmos toxe=1.098480610e-09
altermod pmos ndep=5.699286531e+18
altermod pmos u0=5.494187860e-03
altermod pmos xj=4.572967140e-09
alter m1 w=2.035620305e-08
alter vd dc=9.463435226e-02
alter vg dc=9.132998879e-01
alter vs dc=7.764352611e-01
alter vb dc=9.132998879e-01
option temp=-10.658843
op
let idx = 116
wrdata C:/Users/udhav/DVD-Project/work/comp_pmos_off_10.out idx i(Vd) i(Vg) i(Vs) i(Vb) @m1[id] @m1[igs] @m1[igd] @m1[igcs] @m1[igcd] @m1[igb] @m1[igidl] @m1[igisl] @m1[isub] @m1[ibd] @m1[ibs]
destroy all
altermod pmos vth0=-4.562088193e-01
altermod pmos toxe=1.047076452e-09
altermod pmos ndep=5.227834909e+18
altermod pmos u0=6.061826467e-03
altermod pmos xj=5.306386788e-09
alter m1 w=2.837053797e-08
alter vd dc=9.620392035e-01
alter vg dc=1.026499694e+00
alter vs dc=5.431028307e-02
alter vb dc=1.026499694e+00
option temp=30.373123
op
let idx = 117
wrdata C:/Users/udhav/DVD-Project/work/comp_pmos_off_10.out idx i(Vd) i(Vg) i(Vs) i(Vb) @m1[id] @m1[igs] @m1[igd] @m1[igcs] @m1[igcd] @m1[igb] @m1[igidl] @m1[igisl] @m1[isub] @m1[ibd] @m1[ibs]
destroy all
altermod pmos vth0=-4.041770725e-01
altermod pmos toxe=9.170431684e-10
altermod pmos ndep=5.550143171e+18
altermod pmos u0=6.327245339e-03
altermod pmos xj=4.766006296e-09
alter m1 w=7.549212871e-08
alter vd dc=2.046565446e-01
alter vg dc=9.658777420e-01
alter vs dc=8.300406235e-01
alter vb dc=9.658777420e-01
option temp=-17.832273
op
let idx = 118
wrdata C:/Users/udhav/DVD-Project/work/comp_pmos_off_10.out idx i(Vd) i(Vg) i(Vs) i(Vb) @m1[id] @m1[igs] @m1[igd] @m1[igcs] @m1[igcd] @m1[igb] @m1[igidl] @m1[igisl] @m1[isub] @m1[ibd] @m1[ibs]
destroy all
altermod pmos vth0=-3.884771872e-01
altermod pmos toxe=1.014991494e-09
altermod pmos ndep=5.564468561e+18
altermod pmos u0=6.269767753e-03
altermod pmos xj=5.372764337e-09
alter m1 w=1.192492223e-07
alter vd dc=5.853823835e-01
alter vg dc=9.280910642e-01
alter vs dc=6.070836775e-01
alter vb dc=9.280910642e-01
option temp=18.225815
op
let idx = 119
wrdata C:/Users/udhav/DVD-Project/work/comp_pmos_off_10.out idx i(Vd) i(Vg) i(Vs) i(Vb) @m1[id] @m1[igs] @m1[igd] @m1[igcs] @m1[igcd] @m1[igb] @m1[igidl] @m1[igisl] @m1[isub] @m1[ibd] @m1[ibs]
destroy all
altermod pmos vth0=-4.123394464e-01
altermod pmos toxe=9.189242311e-10
altermod pmos ndep=5.544190144e+18
altermod pmos u0=5.694293423e-03
altermod pmos xj=4.776970200e-09
alter m1 w=7.883685534e-08
alter vd dc=5.883821196e-02
alter vg dc=9.838813785e-01
alter vs dc=6.611102282e-01
alter vb dc=9.838813785e-01
option temp=124.128042
op
let idx = 120
wrdata C:/Users/udhav/DVD-Project/work/comp_pmos_off_10.out idx i(Vd) i(Vg) i(Vs) i(Vb) @m1[id] @m1[igs] @m1[igd] @m1[igcs] @m1[igcd] @m1[igb] @m1[igidl] @m1[igisl] @m1[isub] @m1[ibd] @m1[ibs]
destroy all
altermod pmos vth0=-4.275536326e-01
altermod pmos toxe=1.047979440e-09
altermod pmos ndep=5.834517654e+18
altermod pmos u0=5.793423247e-03
altermod pmos xj=4.999033142e-09
alter m1 w=2.863733823e-08
alter vd dc=8.499440056e-01
alter vg dc=1.041393928e+00
alter vs dc=8.585426934e-02
alter vb dc=1.041393928e+00
option temp=-19.812712
op
let idx = 121
wrdata C:/Users/udhav/DVD-Project/work/comp_pmos_off_10.out idx i(Vd) i(Vg) i(Vs) i(Vb) @m1[id] @m1[igs] @m1[igd] @m1[igcs] @m1[igcd] @m1[igb] @m1[igidl] @m1[igisl] @m1[isub] @m1[ibd] @m1[ibs]
destroy all
altermod pmos vth0=-4.347358690e-01
altermod pmos toxe=1.083182976e-09
altermod pmos ndep=6.018349724e+18
altermod pmos u0=5.411392069e-03
altermod pmos xj=5.437879145e-09
alter m1 w=4.696693326e-08
alter vd dc=9.887587592e-01
alter vg dc=1.042702307e+00
alter vs dc=7.308314441e-01
alter vb dc=1.042702307e+00
option temp=52.928916
op
let idx = 122
wrdata C:/Users/udhav/DVD-Project/work/comp_pmos_off_10.out idx i(Vd) i(Vg) i(Vs) i(Vb) @m1[id] @m1[igs] @m1[igd] @m1[igcs] @m1[igcd] @m1[igb] @m1[igidl] @m1[igisl] @m1[isub] @m1[ibd] @m1[ibs]
destroy all
altermod pmos vth0=-4.183703027e-01
altermod pmos toxe=9.716815233e-10
altermod pmos ndep=5.512160612e+18
altermod pmos u0=5.986233315e-03
altermod pmos xj=5.342502431e-09
alter m1 w=1.190149327e-07
alter vd dc=4.929406747e-02
alter vg dc=9.099161682e-01
alter vs dc=6.658432542e-01
alter vb dc=9.099161682e-01
option temp=14.512862
op
let idx = 123
wrdata C:/Users/udhav/DVD-Project/work/comp_pmos_off_10.out idx i(Vd) i(Vg) i(Vs) i(Vb) @m1[id] @m1[igs] @m1[igd] @m1[igcs] @m1[igcd] @m1[igb] @m1[igidl] @m1[igisl] @m1[isub] @m1[ibd] @m1[ibs]
destroy all
altermod pmos vth0=-4.717154982e-01
altermod pmos toxe=1.045817377e-09
altermod pmos ndep=5.411507073e+18
altermod pmos u0=6.037789559e-03
altermod pmos xj=4.665605334e-09
alter m1 w=1.089191654e-07
alter vd dc=9.189518874e-02
alter vg dc=1.065513524e+00
alter vs dc=8.166685914e-01
alter vb dc=1.065513524e+00
option temp=-14.035189
op
let idx = 124
wrdata C:/Users/udhav/DVD-Project/work/comp_pmos_off_10.out idx i(Vd) i(Vg) i(Vs) i(Vb) @m1[id] @m1[igs] @m1[igd] @m1[igcs] @m1[igcd] @m1[igb] @m1[igidl] @m1[igisl] @m1[isub] @m1[ibd] @m1[ibs]
destroy all
altermod pmos vth0=-4.446785985e-01
altermod pmos toxe=1.003147961e-09
altermod pmos ndep=5.555572046e+18
altermod pmos u0=5.848364640e-03
altermod pmos xj=4.536696384e-09
alter m1 w=2.939093187e-08
alter vd dc=3.026154584e-01
alter vg dc=9.801523932e-01
alter vs dc=2.034938157e-01
alter vb dc=9.801523932e-01
option temp=47.389707
op
let idx = 125
wrdata C:/Users/udhav/DVD-Project/work/comp_pmos_off_10.out idx i(Vd) i(Vg) i(Vs) i(Vb) @m1[id] @m1[igs] @m1[igd] @m1[igcs] @m1[igcd] @m1[igb] @m1[igidl] @m1[igisl] @m1[isub] @m1[ibd] @m1[ibs]
destroy all
altermod pmos vth0=-4.007854643e-01
altermod pmos toxe=9.907123168e-10
altermod pmos ndep=5.524817551e+18
altermod pmos u0=5.600468277e-03
altermod pmos xj=5.361408595e-09
alter m1 w=4.621844396e-08
alter vd dc=7.905029133e-02
alter vg dc=9.478907562e-01
alter vs dc=6.734067135e-01
alter vb dc=9.478907562e-01
option temp=99.138462
op
let idx = 126
wrdata C:/Users/udhav/DVD-Project/work/comp_pmos_off_10.out idx i(Vd) i(Vg) i(Vs) i(Vb) @m1[id] @m1[igs] @m1[igd] @m1[igcs] @m1[igcd] @m1[igb] @m1[igidl] @m1[igisl] @m1[isub] @m1[ibd] @m1[ibs]
destroy all
altermod pmos vth0=-4.386215713e-01
altermod pmos toxe=1.006869185e-09
altermod pmos ndep=5.516682405e+18
altermod pmos u0=6.194228477e-03
altermod pmos xj=4.683186575e-09
alter m1 w=3.497154542e-08
alter vd dc=6.527161465e-01
alter vg dc=9.520788250e-01
alter vs dc=5.630878127e-01
alter vb dc=9.520788250e-01
option temp=68.226761
op
let idx = 127
wrdata C:/Users/udhav/DVD-Project/work/comp_pmos_off_10.out idx i(Vd) i(Vg) i(Vs) i(Vb) @m1[id] @m1[igs] @m1[igd] @m1[igcs] @m1[igcd] @m1[igb] @m1[igidl] @m1[igisl] @m1[isub] @m1[ibd] @m1[ibs]
destroy all
altermod pmos vth0=-4.354199740e-01
altermod pmos toxe=9.602822457e-10
altermod pmos ndep=5.787604615e+18
altermod pmos u0=6.200600008e-03
altermod pmos xj=4.861999121e-09
alter m1 w=2.202273681e-08
alter vd dc=3.169963434e-01
alter vg dc=1.047245925e+00
alter vs dc=2.404582822e-01
alter vb dc=1.047245925e+00
option temp=69.939355
op
let idx = 128
wrdata C:/Users/udhav/DVD-Project/work/comp_pmos_off_10.out idx i(Vd) i(Vg) i(Vs) i(Vb) @m1[id] @m1[igs] @m1[igd] @m1[igcs] @m1[igcd] @m1[igb] @m1[igidl] @m1[igisl] @m1[isub] @m1[ibd] @m1[ibs]
destroy all
altermod pmos vth0=-4.193069881e-01
altermod pmos toxe=1.083533323e-09
altermod pmos ndep=5.270284865e+18
altermod pmos u0=6.172417868e-03
altermod pmos xj=4.848869138e-09
alter m1 w=1.056431855e-07
alter vd dc=8.134938551e-01
alter vg dc=9.466724820e-01
alter vs dc=2.838829353e-01
alter vb dc=9.466724820e-01
option temp=101.659044
op
let idx = 129
wrdata C:/Users/udhav/DVD-Project/work/comp_pmos_off_10.out idx i(Vd) i(Vg) i(Vs) i(Vb) @m1[id] @m1[igs] @m1[igd] @m1[igcs] @m1[igcd] @m1[igb] @m1[igidl] @m1[igisl] @m1[isub] @m1[ibd] @m1[ibs]
destroy all
altermod pmos vth0=-4.336277727e-01
altermod pmos toxe=9.842778504e-10
altermod pmos ndep=5.770120748e+18
altermod pmos u0=6.509894300e-03
altermod pmos xj=5.105293107e-09
alter m1 w=1.090248247e-07
alter vd dc=8.008799112e-02
alter vg dc=9.189788776e-01
alter vs dc=7.221502535e-01
alter vb dc=9.189788776e-01
option temp=-9.070253
op
let idx = 130
wrdata C:/Users/udhav/DVD-Project/work/comp_pmos_off_10.out idx i(Vd) i(Vg) i(Vs) i(Vb) @m1[id] @m1[igs] @m1[igd] @m1[igcs] @m1[igcd] @m1[igb] @m1[igidl] @m1[igisl] @m1[isub] @m1[ibd] @m1[ibs]
destroy all
altermod pmos vth0=-4.516404001e-01
altermod pmos toxe=9.528045697e-10
altermod pmos ndep=4.957080095e+18
altermod pmos u0=5.968355776e-03
altermod pmos xj=5.254823072e-09
alter m1 w=2.432868521e-08
alter vd dc=8.060226626e-02
alter vg dc=1.041398545e+00
alter vs dc=5.501720947e-01
alter vb dc=1.041398545e+00
option temp=-14.443198
op
let idx = 131
wrdata C:/Users/udhav/DVD-Project/work/comp_pmos_off_10.out idx i(Vd) i(Vg) i(Vs) i(Vb) @m1[id] @m1[igs] @m1[igd] @m1[igcs] @m1[igcd] @m1[igb] @m1[igidl] @m1[igisl] @m1[isub] @m1[ibd] @m1[ibs]
destroy all
altermod pmos vth0=-4.450656889e-01
altermod pmos toxe=9.105998856e-10
altermod pmos ndep=5.286538537e+18
altermod pmos u0=6.183585030e-03
altermod pmos xj=5.338002828e-09
alter m1 w=9.592732132e-08
alter vd dc=1.849633546e-01
alter vg dc=9.708158946e-01
alter vs dc=4.495551149e-01
alter vb dc=9.708158946e-01
option temp=92.256270
op
let idx = 132
wrdata C:/Users/udhav/DVD-Project/work/comp_pmos_off_10.out idx i(Vd) i(Vg) i(Vs) i(Vb) @m1[id] @m1[igs] @m1[igd] @m1[igcs] @m1[igcd] @m1[igb] @m1[igidl] @m1[igisl] @m1[isub] @m1[ibd] @m1[ibs]
destroy all
altermod pmos vth0=-4.162977649e-01
altermod pmos toxe=1.045427965e-09
altermod pmos ndep=5.125398177e+18
altermod pmos u0=5.859260279e-03
altermod pmos xj=4.950183227e-09
alter m1 w=5.145032547e-08
alter vd dc=1.737956671e-01
alter vg dc=1.042160715e+00
alter vs dc=4.806488314e-01
alter vb dc=1.042160715e+00
option temp=47.633934
op
let idx = 133
wrdata C:/Users/udhav/DVD-Project/work/comp_pmos_off_10.out idx i(Vd) i(Vg) i(Vs) i(Vb) @m1[id] @m1[igs] @m1[igd] @m1[igcs] @m1[igcd] @m1[igb] @m1[igidl] @m1[igisl] @m1[isub] @m1[ibd] @m1[ibs]
destroy all
altermod pmos vth0=-3.886753613e-01
altermod pmos toxe=9.130573007e-10
altermod pmos ndep=5.636430158e+18
altermod pmos u0=5.733634701e-03
altermod pmos xj=5.117619759e-09
alter m1 w=3.678748988e-08
alter vd dc=3.419676372e-02
alter vg dc=1.060033795e+00
alter vs dc=7.860469728e-01
alter vb dc=1.060033795e+00
option temp=46.304975
op
let idx = 134
wrdata C:/Users/udhav/DVD-Project/work/comp_pmos_off_10.out idx i(Vd) i(Vg) i(Vs) i(Vb) @m1[id] @m1[igs] @m1[igd] @m1[igcs] @m1[igcd] @m1[igb] @m1[igidl] @m1[igisl] @m1[isub] @m1[ibd] @m1[ibs]
destroy all
altermod pmos vth0=-4.348723339e-01
altermod pmos toxe=9.072393433e-10
altermod pmos ndep=5.720867652e+18
altermod pmos u0=6.134451016e-03
altermod pmos xj=5.106253635e-09
alter m1 w=9.722119357e-08
alter vd dc=1.692498737e-01
alter vg dc=9.181138801e-01
alter vs dc=5.826114163e-01
alter vb dc=9.181138801e-01
option temp=38.721565
op
let idx = 135
wrdata C:/Users/udhav/DVD-Project/work/comp_pmos_off_10.out idx i(Vd) i(Vg) i(Vs) i(Vb) @m1[id] @m1[igs] @m1[igd] @m1[igcs] @m1[igcd] @m1[igb] @m1[igidl] @m1[igisl] @m1[isub] @m1[ibd] @m1[ibs]
destroy all
altermod pmos vth0=-4.058530368e-01
altermod pmos toxe=9.520466087e-10
altermod pmos ndep=5.307069988e+18
altermod pmos u0=5.933595186e-03
altermod pmos xj=5.449333393e-09
alter m1 w=5.394824171e-08
alter vd dc=3.771879496e-01
alter vg dc=9.284434519e-01
alter vs dc=7.181165664e-01
alter vb dc=9.284434519e-01
option temp=38.821460
op
let idx = 136
wrdata C:/Users/udhav/DVD-Project/work/comp_pmos_off_10.out idx i(Vd) i(Vg) i(Vs) i(Vb) @m1[id] @m1[igs] @m1[igd] @m1[igcs] @m1[igcd] @m1[igb] @m1[igidl] @m1[igisl] @m1[isub] @m1[ibd] @m1[ibs]
destroy all
altermod pmos vth0=-4.737583507e-01
altermod pmos toxe=9.384422727e-10
altermod pmos ndep=5.454210427e+18
altermod pmos u0=5.733428079e-03
altermod pmos xj=5.137470748e-09
alter m1 w=6.722836524e-08
alter vd dc=9.204113002e-01
alter vg dc=1.046693338e+00
alter vs dc=3.465538598e-01
alter vb dc=1.046693338e+00
option temp=-6.426436
op
let idx = 137
wrdata C:/Users/udhav/DVD-Project/work/comp_pmos_off_10.out idx i(Vd) i(Vg) i(Vs) i(Vb) @m1[id] @m1[igs] @m1[igd] @m1[igcs] @m1[igcd] @m1[igb] @m1[igidl] @m1[igisl] @m1[isub] @m1[ibd] @m1[ibs]
destroy all
altermod pmos vth0=-4.612592246e-01
altermod pmos toxe=9.680120502e-10
altermod pmos ndep=5.339263982e+18
altermod pmos u0=5.883295204e-03
altermod pmos xj=4.530522252e-09
alter m1 w=1.081721250e-07
alter vd dc=5.013557740e-02
alter vg dc=1.006172350e+00
alter vs dc=8.349742709e-01
alter vb dc=1.006172350e+00
option temp=104.288339
op
let idx = 138
wrdata C:/Users/udhav/DVD-Project/work/comp_pmos_off_10.out idx i(Vd) i(Vg) i(Vs) i(Vb) @m1[id] @m1[igs] @m1[igd] @m1[igcs] @m1[igcd] @m1[igb] @m1[igidl] @m1[igisl] @m1[isub] @m1[ibd] @m1[ibs]
destroy all
altermod pmos vth0=-4.103082761e-01
altermod pmos toxe=1.096104468e-09
altermod pmos ndep=5.654192656e+18
altermod pmos u0=6.274211345e-03
altermod pmos xj=5.132586130e-09
alter m1 w=3.864094587e-08
alter vd dc=6.437645798e-01
alter vg dc=9.092592527e-01
alter vs dc=4.543200326e-01
alter vb dc=9.092592527e-01
option temp=-20.824678
op
let idx = 139
wrdata C:/Users/udhav/DVD-Project/work/comp_pmos_off_10.out idx i(Vd) i(Vg) i(Vs) i(Vb) @m1[id] @m1[igs] @m1[igd] @m1[igcs] @m1[igcd] @m1[igb] @m1[igidl] @m1[igisl] @m1[isub] @m1[ibd] @m1[ibs]
destroy all
altermod pmos vth0=-4.722442389e-01
altermod pmos toxe=1.063723257e-09
altermod pmos ndep=5.440945864e+18
altermod pmos u0=5.693945817e-03
altermod pmos xj=4.806612759e-09
alter m1 w=1.084520720e-07
alter vd dc=2.899785572e-01
alter vg dc=1.030071840e+00
alter vs dc=3.087320125e-01
alter vb dc=1.030071840e+00
option temp=78.637447
op
let idx = 140
wrdata C:/Users/udhav/DVD-Project/work/comp_pmos_off_10.out idx i(Vd) i(Vg) i(Vs) i(Vb) @m1[id] @m1[igs] @m1[igd] @m1[igcs] @m1[igcd] @m1[igb] @m1[igidl] @m1[igisl] @m1[isub] @m1[ibd] @m1[ibs]
destroy all
altermod pmos vth0=-4.016740965e-01
altermod pmos toxe=1.039101484e-09
altermod pmos ndep=5.251725203e+18
altermod pmos u0=6.490461740e-03
altermod pmos xj=4.631041511e-09
alter m1 w=4.531328242e-08
alter vd dc=8.811805268e-01
alter vg dc=9.819001195e-01
alter vs dc=7.740364601e-01
alter vb dc=9.819001195e-01
option temp=46.822593
op
let idx = 141
wrdata C:/Users/udhav/DVD-Project/work/comp_pmos_off_10.out idx i(Vd) i(Vg) i(Vs) i(Vb) @m1[id] @m1[igs] @m1[igd] @m1[igcs] @m1[igcd] @m1[igb] @m1[igidl] @m1[igisl] @m1[isub] @m1[ibd] @m1[ibs]
destroy all
altermod pmos vth0=-4.101131741e-01
altermod pmos toxe=9.591799116e-10
altermod pmos ndep=5.102603271e+18
altermod pmos u0=6.122412168e-03
altermod pmos xj=4.688500758e-09
alter m1 w=5.130368762e-08
alter vd dc=2.030416586e-01
alter vg dc=9.456843395e-01
alter vs dc=1.451375820e-01
alter vb dc=9.456843395e-01
option temp=-12.497506
op
let idx = 142
wrdata C:/Users/udhav/DVD-Project/work/comp_pmos_off_10.out idx i(Vd) i(Vg) i(Vs) i(Vb) @m1[id] @m1[igs] @m1[igd] @m1[igcs] @m1[igcd] @m1[igb] @m1[igidl] @m1[igisl] @m1[isub] @m1[ibd] @m1[ibs]
destroy all
altermod pmos vth0=-3.936711502e-01
altermod pmos toxe=1.086250513e-09
altermod pmos ndep=6.006457122e+18
altermod pmos u0=5.601848599e-03
altermod pmos xj=4.809615643e-09
alter m1 w=8.748557334e-08
alter vd dc=2.476524141e-01
alter vg dc=1.051398889e+00
alter vs dc=9.674246065e-01
alter vb dc=1.051398889e+00
option temp=-12.557101
op
let idx = 143
wrdata C:/Users/udhav/DVD-Project/work/comp_pmos_off_10.out idx i(Vd) i(Vg) i(Vs) i(Vb) @m1[id] @m1[igs] @m1[igd] @m1[igcs] @m1[igcd] @m1[igb] @m1[igidl] @m1[igisl] @m1[isub] @m1[ibd] @m1[ibs]
destroy all
altermod pmos vth0=-4.028381679e-01
altermod pmos toxe=9.240534403e-10
altermod pmos ndep=5.930552455e+18
altermod pmos u0=5.758289390e-03
altermod pmos xj=4.968791644e-09
alter m1 w=1.025067984e-07
alter vd dc=8.394468352e-01
alter vg dc=1.048444788e+00
alter vs dc=3.016260420e-02
alter vb dc=1.048444788e+00
option temp=-7.910177
op
let idx = 144
wrdata C:/Users/udhav/DVD-Project/work/comp_pmos_off_10.out idx i(Vd) i(Vg) i(Vs) i(Vb) @m1[id] @m1[igs] @m1[igd] @m1[igcs] @m1[igcd] @m1[igb] @m1[igidl] @m1[igisl] @m1[isub] @m1[ibd] @m1[ibs]
destroy all
altermod pmos vth0=-4.268945239e-01
altermod pmos toxe=1.001215737e-09
altermod pmos ndep=5.888223749e+18
altermod pmos u0=6.273956734e-03
altermod pmos xj=4.686618789e-09
alter m1 w=2.277680341e-08
alter vd dc=3.104271009e-01
alter vg dc=9.627297466e-01
alter vs dc=3.804629480e-02
alter vb dc=9.627297466e-01
option temp=-0.890310
op
let idx = 145
wrdata C:/Users/udhav/DVD-Project/work/comp_pmos_off_10.out idx i(Vd) i(Vg) i(Vs) i(Vb) @m1[id] @m1[igs] @m1[igd] @m1[igcs] @m1[igcd] @m1[igb] @m1[igidl] @m1[igisl] @m1[isub] @m1[ibd] @m1[ibs]
destroy all
altermod pmos vth0=-4.623623928e-01
altermod pmos toxe=9.011376303e-10
altermod pmos ndep=5.654324442e+18
altermod pmos u0=6.391480222e-03
altermod pmos xj=4.576343826e-09
alter m1 w=1.264005425e-07
alter vd dc=9.224223766e-01
alter vg dc=1.025010364e+00
alter vs dc=8.985178921e-01
alter vb dc=1.025010364e+00
option temp=-3.024599
op
let idx = 146
wrdata C:/Users/udhav/DVD-Project/work/comp_pmos_off_10.out idx i(Vd) i(Vg) i(Vs) i(Vb) @m1[id] @m1[igs] @m1[igd] @m1[igcs] @m1[igcd] @m1[igb] @m1[igidl] @m1[igisl] @m1[isub] @m1[ibd] @m1[ibs]
destroy all
altermod pmos vth0=-4.131850353e-01
altermod pmos toxe=1.086987937e-09
altermod pmos ndep=5.822203415e+18
altermod pmos u0=6.303789065e-03
altermod pmos xj=5.269001223e-09
alter m1 w=4.015931057e-08
alter vd dc=3.800019165e-01
alter vg dc=1.062461125e+00
alter vs dc=2.436152341e-02
alter vb dc=1.062461125e+00
option temp=-37.347485
op
let idx = 147
wrdata C:/Users/udhav/DVD-Project/work/comp_pmos_off_10.out idx i(Vd) i(Vg) i(Vs) i(Vb) @m1[id] @m1[igs] @m1[igd] @m1[igcs] @m1[igcd] @m1[igb] @m1[igidl] @m1[igisl] @m1[isub] @m1[ibd] @m1[ibs]
destroy all
altermod pmos vth0=-4.273170561e-01
altermod pmos toxe=9.818151045e-10
altermod pmos ndep=5.383340861e+18
altermod pmos u0=6.587877130e-03
altermod pmos xj=4.618925372e-09
alter m1 w=1.144857677e-07
alter vd dc=6.660427115e-02
alter vg dc=1.099403109e+00
alter vs dc=2.043019828e-01
alter vb dc=1.099403109e+00
option temp=114.077783
op
let idx = 148
wrdata C:/Users/udhav/DVD-Project/work/comp_pmos_off_10.out idx i(Vd) i(Vg) i(Vs) i(Vb) @m1[id] @m1[igs] @m1[igd] @m1[igcs] @m1[igcd] @m1[igb] @m1[igidl] @m1[igisl] @m1[isub] @m1[ibd] @m1[ibs]
destroy all
altermod pmos vth0=-4.261842554e-01
altermod pmos toxe=9.824380911e-10
altermod pmos ndep=5.956595036e+18
altermod pmos u0=5.667743964e-03
altermod pmos xj=5.472370391e-09
alter m1 w=2.806040384e-08
alter vd dc=8.477570715e-01
alter vg dc=1.033033921e+00
alter vs dc=9.703264607e-01
alter vb dc=1.033033921e+00
option temp=47.311999
op
let idx = 149
wrdata C:/Users/udhav/DVD-Project/work/comp_pmos_off_10.out idx i(Vd) i(Vg) i(Vs) i(Vb) @m1[id] @m1[igs] @m1[igd] @m1[igcs] @m1[igcd] @m1[igb] @m1[igidl] @m1[igisl] @m1[isub] @m1[ibd] @m1[ibs]
destroy all
altermod pmos vth0=-4.674794655e-01
altermod pmos toxe=1.008946571e-09
altermod pmos ndep=5.625400187e+18
altermod pmos u0=6.245890760e-03
altermod pmos xj=4.680292357e-09
alter m1 w=5.138043479e-08
alter vd dc=2.432462601e-01
alter vg dc=1.097962300e+00
alter vs dc=6.693224348e-01
alter vb dc=1.097962300e+00
option temp=-16.035270
op
let idx = 150
wrdata C:/Users/udhav/DVD-Project/work/comp_pmos_off_10.out idx i(Vd) i(Vg) i(Vs) i(Vb) @m1[id] @m1[igs] @m1[igd] @m1[igcs] @m1[igcd] @m1[igb] @m1[igidl] @m1[igisl] @m1[isub] @m1[ibd] @m1[ibs]
destroy all
altermod pmos vth0=-4.142164954e-01
altermod pmos toxe=9.694488799e-10
altermod pmos ndep=5.575053111e+18
altermod pmos u0=6.176817770e-03
altermod pmos xj=5.190445994e-09
alter m1 w=8.536729322e-08
alter vd dc=6.452649591e-02
alter vg dc=9.407589414e-01
alter vs dc=2.532056416e-02
alter vb dc=9.407589414e-01
option temp=115.422006
op
let idx = 151
wrdata C:/Users/udhav/DVD-Project/work/comp_pmos_off_10.out idx i(Vd) i(Vg) i(Vs) i(Vb) @m1[id] @m1[igs] @m1[igd] @m1[igcs] @m1[igcd] @m1[igb] @m1[igidl] @m1[igisl] @m1[isub] @m1[ibd] @m1[ibs]
destroy all
altermod pmos vth0=-4.270876421e-01
altermod pmos toxe=9.477671774e-10
altermod pmos ndep=6.035524434e+18
altermod pmos u0=5.517193768e-03
altermod pmos xj=4.757392902e-09
alter m1 w=3.387184433e-08
alter vd dc=8.600392361e-01
alter vg dc=9.569110056e-01
alter vs dc=4.230466586e-01
alter vb dc=9.569110056e-01
option temp=117.736096
op
let idx = 152
wrdata C:/Users/udhav/DVD-Project/work/comp_pmos_off_10.out idx i(Vd) i(Vg) i(Vs) i(Vb) @m1[id] @m1[igs] @m1[igd] @m1[igcs] @m1[igcd] @m1[igb] @m1[igidl] @m1[igisl] @m1[isub] @m1[ibd] @m1[ibs]
destroy all
altermod pmos vth0=-4.447369743e-01
altermod pmos toxe=9.464409422e-10
altermod pmos ndep=5.836757990e+18
altermod pmos u0=6.171659521e-03
altermod pmos xj=4.970807026e-09
alter m1 w=1.054852627e-07
alter vd dc=5.174629551e-02
alter vg dc=1.093652106e+00
alter vs dc=7.361905231e-01
alter vb dc=1.093652106e+00
option temp=55.194568
op
let idx = 153
wrdata C:/Users/udhav/DVD-Project/work/comp_pmos_off_10.out idx i(Vd) i(Vg) i(Vs) i(Vb) @m1[id] @m1[igs] @m1[igd] @m1[igcs] @m1[igcd] @m1[igb] @m1[igidl] @m1[igisl] @m1[isub] @m1[ibd] @m1[ibs]
destroy all
altermod pmos vth0=-4.478138104e-01
altermod pmos toxe=9.511744777e-10
altermod pmos ndep=5.705913287e+18
altermod pmos u0=6.229091179e-03
altermod pmos xj=4.573904866e-09
alter m1 w=9.285814547e-08
alter vd dc=4.981196198e-01
alter vg dc=9.391505097e-01
alter vs dc=5.035349770e-01
alter vb dc=9.391505097e-01
option temp=77.656351
op
let idx = 154
wrdata C:/Users/udhav/DVD-Project/work/comp_pmos_off_10.out idx i(Vd) i(Vg) i(Vs) i(Vb) @m1[id] @m1[igs] @m1[igd] @m1[igcs] @m1[igcd] @m1[igb] @m1[igidl] @m1[igisl] @m1[isub] @m1[ibd] @m1[ibs]
destroy all
altermod pmos vth0=-4.093322810e-01
altermod pmos toxe=1.089757294e-09
altermod pmos ndep=5.130104407e+18
altermod pmos u0=5.834560824e-03
altermod pmos xj=5.370971783e-09
alter m1 w=1.048055830e-07
alter vd dc=4.915740472e-01
alter vg dc=9.145223186e-01
alter vs dc=5.865451109e-01
alter vb dc=9.145223186e-01
option temp=104.292275
op
let idx = 155
wrdata C:/Users/udhav/DVD-Project/work/comp_pmos_off_10.out idx i(Vd) i(Vg) i(Vs) i(Vb) @m1[id] @m1[igs] @m1[igd] @m1[igcs] @m1[igcd] @m1[igb] @m1[igidl] @m1[igisl] @m1[isub] @m1[ibd] @m1[ibs]
destroy all
altermod pmos vth0=-4.332635994e-01
altermod pmos toxe=9.481490307e-10
altermod pmos ndep=5.136915617e+18
altermod pmos u0=6.310177894e-03
altermod pmos xj=4.567756113e-09
alter m1 w=5.841447549e-08
alter vd dc=5.774402303e-01
alter vg dc=1.078043358e+00
alter vs dc=8.043067494e-01
alter vb dc=1.078043358e+00
option temp=57.486422
op
let idx = 156
wrdata C:/Users/udhav/DVD-Project/work/comp_pmos_off_10.out idx i(Vd) i(Vg) i(Vs) i(Vb) @m1[id] @m1[igs] @m1[igd] @m1[igcs] @m1[igcd] @m1[igb] @m1[igidl] @m1[igisl] @m1[isub] @m1[ibd] @m1[ibs]
destroy all
altermod pmos vth0=-4.290719465e-01
altermod pmos toxe=1.008958328e-09
altermod pmos ndep=5.952468453e+18
altermod pmos u0=6.226399845e-03
altermod pmos xj=4.508976403e-09
alter m1 w=7.749844912e-08
alter vd dc=7.159176079e-01
alter vg dc=9.746038573e-01
alter vs dc=2.446561127e-01
alter vb dc=9.746038573e-01
option temp=-20.747572
op
let idx = 157
wrdata C:/Users/udhav/DVD-Project/work/comp_pmos_off_10.out idx i(Vd) i(Vg) i(Vs) i(Vb) @m1[id] @m1[igs] @m1[igd] @m1[igcs] @m1[igcd] @m1[igb] @m1[igidl] @m1[igisl] @m1[isub] @m1[ibd] @m1[ibs]
destroy all
altermod pmos vth0=-3.957161357e-01
altermod pmos toxe=9.596334326e-10
altermod pmos ndep=5.097558051e+18
altermod pmos u0=6.383155865e-03
altermod pmos xj=4.927849521e-09
alter m1 w=8.307760430e-08
alter vd dc=4.719215478e-02
alter vg dc=9.063825108e-01
alter vs dc=7.893835076e-01
alter vb dc=9.063825108e-01
option temp=-16.964931
op
let idx = 158
wrdata C:/Users/udhav/DVD-Project/work/comp_pmos_off_10.out idx i(Vd) i(Vg) i(Vs) i(Vb) @m1[id] @m1[igs] @m1[igd] @m1[igcs] @m1[igcd] @m1[igb] @m1[igidl] @m1[igisl] @m1[isub] @m1[ibd] @m1[ibs]
destroy all
altermod pmos vth0=-4.159495391e-01
altermod pmos toxe=9.703535412e-10
altermod pmos ndep=6.046934545e+18
altermod pmos u0=6.407506490e-03
altermod pmos xj=4.666260152e-09
alter m1 w=5.510131024e-08
alter vd dc=7.361898917e-01
alter vg dc=9.394158404e-01
alter vs dc=6.880523952e-01
alter vb dc=9.394158404e-01
option temp=0.049677
op
let idx = 159
wrdata C:/Users/udhav/DVD-Project/work/comp_pmos_off_10.out idx i(Vd) i(Vg) i(Vs) i(Vb) @m1[id] @m1[igs] @m1[igd] @m1[igcs] @m1[igcd] @m1[igb] @m1[igidl] @m1[igisl] @m1[isub] @m1[ibd] @m1[ibs]
destroy all
altermod pmos vth0=-3.962232399e-01
altermod pmos toxe=9.032387157e-10
altermod pmos ndep=5.861079901e+18
altermod pmos u0=6.423661764e-03
altermod pmos xj=4.639649081e-09
alter m1 w=2.475451049e-08
alter vd dc=6.328435525e-01
alter vg dc=1.018478924e+00
alter vs dc=4.328226043e-01
alter vb dc=1.018478924e+00
option temp=54.243505
op
let idx = 160
wrdata C:/Users/udhav/DVD-Project/work/comp_pmos_off_10.out idx i(Vd) i(Vg) i(Vs) i(Vb) @m1[id] @m1[igs] @m1[igd] @m1[igcs] @m1[igcd] @m1[igb] @m1[igidl] @m1[igisl] @m1[isub] @m1[ibd] @m1[ibs]
destroy all
altermod pmos vth0=-4.687096393e-01
altermod pmos toxe=9.509223870e-10
altermod pmos ndep=5.459756372e+18
altermod pmos u0=5.558343393e-03
altermod pmos xj=5.216036202e-09
alter m1 w=9.918121282e-08
alter vd dc=9.165975591e-01
alter vg dc=9.697733739e-01
alter vs dc=1.601464676e-01
alter vb dc=9.697733739e-01
option temp=87.732384
op
let idx = 161
wrdata C:/Users/udhav/DVD-Project/work/comp_pmos_off_10.out idx i(Vd) i(Vg) i(Vs) i(Vb) @m1[id] @m1[igs] @m1[igd] @m1[igcs] @m1[igcd] @m1[igb] @m1[igidl] @m1[igisl] @m1[isub] @m1[ibd] @m1[ibs]
destroy all
altermod pmos vth0=-4.655499989e-01
altermod pmos toxe=1.009872370e-09
altermod pmos ndep=5.609101704e+18
altermod pmos u0=6.046328248e-03
altermod pmos xj=4.654711047e-09
alter m1 w=1.216723853e-07
alter vd dc=1.226358108e-01
alter vg dc=9.403904692e-01
alter vs dc=6.605546423e-01
alter vb dc=9.403904692e-01
option temp=119.815821
op
let idx = 162
wrdata C:/Users/udhav/DVD-Project/work/comp_pmos_off_10.out idx i(Vd) i(Vg) i(Vs) i(Vb) @m1[id] @m1[igs] @m1[igd] @m1[igcs] @m1[igcd] @m1[igb] @m1[igidl] @m1[igisl] @m1[isub] @m1[ibd] @m1[ibs]
destroy all
altermod pmos vth0=-4.163085467e-01
altermod pmos toxe=9.211185582e-10
altermod pmos ndep=5.543013159e+18
altermod pmos u0=6.315054984e-03
altermod pmos xj=4.792860758e-09
alter m1 w=7.824125507e-08
alter vd dc=7.792039050e-01
alter vg dc=9.853615975e-01
alter vs dc=8.779894475e-01
alter vb dc=9.853615975e-01
option temp=66.585362
op
let idx = 163
wrdata C:/Users/udhav/DVD-Project/work/comp_pmos_off_10.out idx i(Vd) i(Vg) i(Vs) i(Vb) @m1[id] @m1[igs] @m1[igd] @m1[igcs] @m1[igcd] @m1[igb] @m1[igidl] @m1[igisl] @m1[isub] @m1[ibd] @m1[ibs]
destroy all
altermod pmos vth0=-4.511036003e-01
altermod pmos toxe=1.016708096e-09
altermod pmos ndep=5.947540621e+18
altermod pmos u0=6.309258305e-03
altermod pmos xj=5.420877757e-09
alter m1 w=1.175484864e-07
alter vd dc=2.338521817e-01
alter vg dc=9.005619593e-01
alter vs dc=8.820746647e-01
alter vb dc=9.005619593e-01
option temp=92.830129
op
let idx = 164
wrdata C:/Users/udhav/DVD-Project/work/comp_pmos_off_10.out idx i(Vd) i(Vg) i(Vs) i(Vb) @m1[id] @m1[igs] @m1[igd] @m1[igcs] @m1[igcd] @m1[igb] @m1[igidl] @m1[igisl] @m1[isub] @m1[ibd] @m1[ibs]
destroy all
altermod pmos vth0=-4.492571161e-01
altermod pmos toxe=9.721443899e-10
altermod pmos ndep=5.378394724e+18
altermod pmos u0=5.445468576e-03
altermod pmos xj=4.989317001e-09
alter m1 w=7.394345462e-08
alter vd dc=4.479756344e-01
alter vg dc=1.027676643e+00
alter vs dc=9.246262022e-02
alter vb dc=1.027676643e+00
option temp=87.665287
op
let idx = 165
wrdata C:/Users/udhav/DVD-Project/work/comp_pmos_off_10.out idx i(Vd) i(Vg) i(Vs) i(Vb) @m1[id] @m1[igs] @m1[igd] @m1[igcs] @m1[igcd] @m1[igb] @m1[igidl] @m1[igisl] @m1[isub] @m1[ibd] @m1[ibs]
destroy all
altermod pmos vth0=-4.643264073e-01
altermod pmos toxe=1.031967353e-09
altermod pmos ndep=5.969062613e+18
altermod pmos u0=5.793265330e-03
altermod pmos xj=5.432932157e-09
alter m1 w=4.817492154e-08
alter vd dc=2.774166850e-01
alter vg dc=1.097249603e+00
alter vs dc=1.026674395e+00
alter vb dc=1.097249603e+00
option temp=41.464189
op
let idx = 166
wrdata C:/Users/udhav/DVD-Project/work/comp_pmos_off_10.out idx i(Vd) i(Vg) i(Vs) i(Vb) @m1[id] @m1[igs] @m1[igd] @m1[igcs] @m1[igcd] @m1[igb] @m1[igidl] @m1[igisl] @m1[isub] @m1[ibd] @m1[ibs]
destroy all
altermod pmos vth0=-4.487659250e-01
altermod pmos toxe=1.014383541e-09
altermod pmos ndep=5.474371430e+18
altermod pmos u0=6.580088712e-03
altermod pmos xj=5.482912721e-09
alter m1 w=6.367712877e-08
alter vd dc=1.480964473e-02
alter vg dc=9.026026453e-01
alter vs dc=5.803609912e-01
alter vb dc=9.026026453e-01
option temp=47.180262
op
let idx = 167
wrdata C:/Users/udhav/DVD-Project/work/comp_pmos_off_10.out idx i(Vd) i(Vg) i(Vs) i(Vb) @m1[id] @m1[igs] @m1[igd] @m1[igcs] @m1[igcd] @m1[igb] @m1[igidl] @m1[igisl] @m1[isub] @m1[ibd] @m1[ibs]
destroy all
altermod pmos vth0=-3.988074331e-01
altermod pmos toxe=1.007539704e-09
altermod pmos ndep=5.197619145e+18
altermod pmos u0=5.833114042e-03
altermod pmos xj=4.708464879e-09
alter m1 w=6.326967757e-08
alter vd dc=3.822232213e-01
alter vg dc=1.037724189e+00
alter vs dc=4.092198440e-01
alter vb dc=1.037724189e+00
option temp=0.142652
op
let idx = 168
wrdata C:/Users/udhav/DVD-Project/work/comp_pmos_off_10.out idx i(Vd) i(Vg) i(Vs) i(Vb) @m1[id] @m1[igs] @m1[igd] @m1[igcs] @m1[igcd] @m1[igb] @m1[igidl] @m1[igisl] @m1[isub] @m1[ibd] @m1[ibs]
destroy all
altermod pmos vth0=-4.335350572e-01
altermod pmos toxe=9.869895096e-10
altermod pmos ndep=5.607899500e+18
altermod pmos u0=5.595101687e-03
altermod pmos xj=5.336403634e-09
alter m1 w=1.160805781e-07
alter vd dc=9.598467306e-02
alter vg dc=1.032550461e+00
alter vs dc=6.437440584e-01
alter vb dc=1.032550461e+00
option temp=59.441537
op
let idx = 169
wrdata C:/Users/udhav/DVD-Project/work/comp_pmos_off_10.out idx i(Vd) i(Vg) i(Vs) i(Vb) @m1[id] @m1[igs] @m1[igd] @m1[igcs] @m1[igcd] @m1[igb] @m1[igidl] @m1[igisl] @m1[isub] @m1[ibd] @m1[ibs]
destroy all
altermod pmos vth0=-4.435918433e-01
altermod pmos toxe=9.260856065e-10
altermod pmos ndep=5.971771719e+18
altermod pmos u0=5.768951056e-03
altermod pmos xj=5.084522619e-09
alter m1 w=8.365155519e-08
alter vd dc=5.241127584e-02
alter vg dc=9.693688782e-01
alter vs dc=6.975065524e-01
alter vb dc=9.693688782e-01
option temp=111.477508
op
let idx = 170
wrdata C:/Users/udhav/DVD-Project/work/comp_pmos_off_10.out idx i(Vd) i(Vg) i(Vs) i(Vb) @m1[id] @m1[igs] @m1[igd] @m1[igcs] @m1[igcd] @m1[igb] @m1[igidl] @m1[igisl] @m1[isub] @m1[ibd] @m1[ibs]
destroy all
altermod pmos vth0=-4.078883343e-01
altermod pmos toxe=9.196309738e-10
altermod pmos ndep=5.187861825e+18
altermod pmos u0=5.668859894e-03
altermod pmos xj=5.196201922e-09
alter m1 w=9.191253160e-08
alter vd dc=3.326080409e-01
alter vg dc=1.051818232e+00
alter vs dc=6.530693149e-01
alter vb dc=1.051818232e+00
option temp=116.507315
op
let idx = 171
wrdata C:/Users/udhav/DVD-Project/work/comp_pmos_off_10.out idx i(Vd) i(Vg) i(Vs) i(Vb) @m1[id] @m1[igs] @m1[igd] @m1[igcs] @m1[igcd] @m1[igb] @m1[igidl] @m1[igisl] @m1[isub] @m1[ibd] @m1[ibs]
destroy all
altermod pmos vth0=-4.597961660e-01
altermod pmos toxe=1.035289351e-09
altermod pmos ndep=5.807906632e+18
altermod pmos u0=5.424582615e-03
altermod pmos xj=4.638070144e-09
alter m1 w=1.253348130e-07
alter vd dc=1.044546636e+00
alter vg dc=1.067423726e+00
alter vs dc=9.549442734e-01
alter vb dc=1.067423726e+00
option temp=101.865599
op
let idx = 172
wrdata C:/Users/udhav/DVD-Project/work/comp_pmos_off_10.out idx i(Vd) i(Vg) i(Vs) i(Vb) @m1[id] @m1[igs] @m1[igd] @m1[igcs] @m1[igcd] @m1[igb] @m1[igidl] @m1[igisl] @m1[isub] @m1[ibd] @m1[ibs]
destroy all
altermod pmos vth0=-4.608611061e-01
altermod pmos toxe=9.706838401e-10
altermod pmos ndep=5.170687410e+18
altermod pmos u0=6.276463046e-03
altermod pmos xj=4.662786849e-09
alter m1 w=5.696710844e-08
alter vd dc=4.768188484e-01
alter vg dc=9.963952007e-01
alter vs dc=6.888980031e-03
alter vb dc=9.963952007e-01
option temp=110.928547
op
let idx = 173
wrdata C:/Users/udhav/DVD-Project/work/comp_pmos_off_10.out idx i(Vd) i(Vg) i(Vs) i(Vb) @m1[id] @m1[igs] @m1[igd] @m1[igcs] @m1[igcd] @m1[igb] @m1[igidl] @m1[igisl] @m1[isub] @m1[ibd] @m1[ibs]
destroy all
altermod pmos vth0=-4.639542188e-01
altermod pmos toxe=1.047378767e-09
altermod pmos ndep=5.854355902e+18
altermod pmos u0=5.966840428e-03
altermod pmos xj=4.684572059e-09
alter m1 w=1.778793613e-08
alter vd dc=2.332699861e-01
alter vg dc=1.086982788e+00
alter vs dc=1.439752935e-01
alter vb dc=1.086982788e+00
option temp=6.202175
op
let idx = 174
wrdata C:/Users/udhav/DVD-Project/work/comp_pmos_off_10.out idx i(Vd) i(Vg) i(Vs) i(Vb) @m1[id] @m1[igs] @m1[igd] @m1[igcs] @m1[igcd] @m1[igb] @m1[igidl] @m1[igisl] @m1[isub] @m1[ibd] @m1[ibs]
destroy all
altermod pmos vth0=-4.370095906e-01
altermod pmos toxe=1.075049833e-09
altermod pmos ndep=5.741246554e+18
altermod pmos u0=6.547799263e-03
altermod pmos xj=5.138679746e-09
alter m1 w=3.231482351e-08
alter vd dc=7.336796062e-01
alter vg dc=9.620997215e-01
alter vs dc=6.407485782e-01
alter vb dc=9.620997215e-01
option temp=89.508070
op
let idx = 175
wrdata C:/Users/udhav/DVD-Project/work/comp_pmos_off_10.out idx i(Vd) i(Vg) i(Vs) i(Vb) @m1[id] @m1[igs] @m1[igd] @m1[igcs] @m1[igcd] @m1[igb] @m1[igidl] @m1[igisl] @m1[isub] @m1[ibd] @m1[ibs]
destroy all
altermod pmos vth0=-4.526796701e-01
altermod pmos toxe=1.077944808e-09
altermod pmos ndep=4.983113697e+18
altermod pmos u0=6.402512024e-03
altermod pmos xj=5.292953610e-09
alter m1 w=1.166088411e-07
alter vd dc=9.875826827e-01
alter vg dc=1.024159551e+00
alter vs dc=5.902291301e-01
alter vb dc=1.024159551e+00
option temp=84.491186
op
let idx = 176
wrdata C:/Users/udhav/DVD-Project/work/comp_pmos_off_10.out idx i(Vd) i(Vg) i(Vs) i(Vb) @m1[id] @m1[igs] @m1[igd] @m1[igcs] @m1[igcd] @m1[igb] @m1[igidl] @m1[igisl] @m1[isub] @m1[ibd] @m1[ibs]
destroy all
altermod pmos vth0=-4.623244465e-01
altermod pmos toxe=9.561737384e-10
altermod pmos ndep=6.007932829e+18
altermod pmos u0=6.041239410e-03
altermod pmos xj=5.293222937e-09
alter m1 w=2.049597727e-08
alter vd dc=4.471824362e-01
alter vg dc=1.017013653e+00
alter vs dc=6.939964290e-01
alter vb dc=1.017013653e+00
option temp=13.480134
op
let idx = 177
wrdata C:/Users/udhav/DVD-Project/work/comp_pmos_off_10.out idx i(Vd) i(Vg) i(Vs) i(Vb) @m1[id] @m1[igs] @m1[igd] @m1[igcs] @m1[igcd] @m1[igb] @m1[igidl] @m1[igisl] @m1[isub] @m1[ibd] @m1[ibs]
destroy all
altermod pmos vth0=-4.163646654e-01
altermod pmos toxe=9.749485129e-10
altermod pmos ndep=5.863329940e+18
altermod pmos u0=5.999258501e-03
altermod pmos xj=5.385167647e-09
alter m1 w=2.759958618e-08
alter vd dc=1.022634892e+00
alter vg dc=1.035286025e+00
alter vs dc=9.899980548e-01
alter vb dc=1.035286025e+00
option temp=12.943647
op
let idx = 178
wrdata C:/Users/udhav/DVD-Project/work/comp_pmos_off_10.out idx i(Vd) i(Vg) i(Vs) i(Vb) @m1[id] @m1[igs] @m1[igd] @m1[igcs] @m1[igcd] @m1[igb] @m1[igidl] @m1[igisl] @m1[isub] @m1[ibd] @m1[ibs]
destroy all
altermod pmos vth0=-3.944896216e-01
altermod pmos toxe=9.944008716e-10
altermod pmos ndep=5.333277355e+18
altermod pmos u0=5.864811371e-03
altermod pmos xj=5.046624092e-09
alter m1 w=7.614586043e-08
alter vd dc=2.230338188e-01
alter vg dc=9.275155464e-01
alter vs dc=5.473608961e-01
alter vb dc=9.275155464e-01
option temp=122.083515
op
let idx = 179
wrdata C:/Users/udhav/DVD-Project/work/comp_pmos_off_10.out idx i(Vd) i(Vg) i(Vs) i(Vb) @m1[id] @m1[igs] @m1[igd] @m1[igcs] @m1[igcd] @m1[igb] @m1[igidl] @m1[igisl] @m1[isub] @m1[ibd] @m1[ibs]
destroy all
altermod pmos vth0=-4.348320321e-01
altermod pmos toxe=1.077496747e-09
altermod pmos ndep=6.048256842e+18
altermod pmos u0=5.545439719e-03
altermod pmos xj=4.989284899e-09
alter m1 w=1.253312686e-07
alter vd dc=1.404104576e-01
alter vg dc=9.582708253e-01
alter vs dc=1.738670851e-01
alter vb dc=9.582708253e-01
option temp=119.813331
op
let idx = 180
wrdata C:/Users/udhav/DVD-Project/work/comp_pmos_off_10.out idx i(Vd) i(Vg) i(Vs) i(Vb) @m1[id] @m1[igs] @m1[igd] @m1[igcs] @m1[igcd] @m1[igb] @m1[igidl] @m1[igisl] @m1[isub] @m1[ibd] @m1[ibs]
destroy all
altermod pmos vth0=-4.115071693e-01
altermod pmos toxe=9.146724290e-10
altermod pmos ndep=5.047607291e+18
altermod pmos u0=5.731767544e-03
altermod pmos xj=5.396670202e-09
alter m1 w=9.207677414e-08
alter vd dc=6.593605392e-01
alter vg dc=9.252970809e-01
alter vs dc=3.763993923e-01
alter vb dc=9.252970809e-01
option temp=53.437392
op
let idx = 181
wrdata C:/Users/udhav/DVD-Project/work/comp_pmos_off_10.out idx i(Vd) i(Vg) i(Vs) i(Vb) @m1[id] @m1[igs] @m1[igd] @m1[igcs] @m1[igcd] @m1[igb] @m1[igidl] @m1[igisl] @m1[isub] @m1[ibd] @m1[ibs]
destroy all
altermod pmos vth0=-4.266247108e-01
altermod pmos toxe=9.234825470e-10
altermod pmos ndep=6.005517104e+18
altermod pmos u0=6.377356762e-03
altermod pmos xj=5.355536542e-09
alter m1 w=1.214117822e-07
alter vd dc=2.322649151e-01
alter vg dc=9.465261270e-01
alter vs dc=4.450641318e-01
alter vb dc=9.465261270e-01
option temp=-19.526176
op
let idx = 182
wrdata C:/Users/udhav/DVD-Project/work/comp_pmos_off_10.out idx i(Vd) i(Vg) i(Vs) i(Vb) @m1[id] @m1[igs] @m1[igd] @m1[igcs] @m1[igcd] @m1[igb] @m1[igidl] @m1[igisl] @m1[isub] @m1[ibd] @m1[ibs]
destroy all
altermod pmos vth0=-4.499155329e-01
altermod pmos toxe=9.090746357e-10
altermod pmos ndep=5.745168064e+18
altermod pmos u0=6.597521787e-03
altermod pmos xj=4.697103705e-09
alter m1 w=1.269535853e-07
alter vd dc=1.858020658e-01
alter vg dc=9.454283216e-01
alter vs dc=6.231434363e-01
alter vb dc=9.454283216e-01
option temp=-18.095804
op
let idx = 183
wrdata C:/Users/udhav/DVD-Project/work/comp_pmos_off_10.out idx i(Vd) i(Vg) i(Vs) i(Vb) @m1[id] @m1[igs] @m1[igd] @m1[igcs] @m1[igcd] @m1[igb] @m1[igidl] @m1[igisl] @m1[isub] @m1[ibd] @m1[ibs]
destroy all
altermod pmos vth0=-4.503702489e-01
altermod pmos toxe=1.061163454e-09
altermod pmos ndep=5.556856247e+18
altermod pmos u0=6.107864963e-03
altermod pmos xj=4.824139827e-09
alter m1 w=7.424341221e-08
alter vd dc=3.321180797e-01
alter vg dc=1.035317222e+00
alter vs dc=6.427233267e-01
alter vb dc=1.035317222e+00
option temp=-30.797069
op
let idx = 184
wrdata C:/Users/udhav/DVD-Project/work/comp_pmos_off_10.out idx i(Vd) i(Vg) i(Vs) i(Vb) @m1[id] @m1[igs] @m1[igd] @m1[igcs] @m1[igcd] @m1[igb] @m1[igidl] @m1[igisl] @m1[isub] @m1[ibd] @m1[ibs]
destroy all
altermod pmos vth0=-4.479368933e-01
altermod pmos toxe=9.712823344e-10
altermod pmos ndep=5.174106984e+18
altermod pmos u0=6.448487225e-03
altermod pmos xj=5.106497459e-09
alter m1 w=8.933287507e-08
alter vd dc=6.541074820e-01
alter vg dc=9.253700988e-01
alter vs dc=9.417965611e-02
alter vb dc=9.253700988e-01
option temp=117.846966
op
let idx = 185
wrdata C:/Users/udhav/DVD-Project/work/comp_pmos_off_10.out idx i(Vd) i(Vg) i(Vs) i(Vb) @m1[id] @m1[igs] @m1[igd] @m1[igcs] @m1[igcd] @m1[igb] @m1[igidl] @m1[igisl] @m1[isub] @m1[ibd] @m1[ibs]
destroy all
altermod pmos vth0=-4.323679210e-01
altermod pmos toxe=1.013637891e-09
altermod pmos ndep=5.633900209e+18
altermod pmos u0=6.084099865e-03
altermod pmos xj=4.993755886e-09
alter m1 w=1.077464579e-07
alter vd dc=9.468616244e-01
alter vg dc=9.946466652e-01
alter vs dc=8.028190887e-01
alter vb dc=9.946466652e-01
option temp=49.969896
op
let idx = 186
wrdata C:/Users/udhav/DVD-Project/work/comp_pmos_off_10.out idx i(Vd) i(Vg) i(Vs) i(Vb) @m1[id] @m1[igs] @m1[igd] @m1[igcs] @m1[igcd] @m1[igb] @m1[igidl] @m1[igisl] @m1[isub] @m1[ibd] @m1[ibs]
destroy all
altermod pmos vth0=-4.471274275e-01
altermod pmos toxe=1.026624887e-09
altermod pmos ndep=5.133885011e+18
altermod pmos u0=6.242660235e-03
altermod pmos xj=4.569157815e-09
alter m1 w=9.643619102e-08
alter vd dc=1.361357408e-01
alter vg dc=9.811885156e-01
alter vs dc=9.784321152e-01
alter vb dc=9.811885156e-01
option temp=120.150238
op
let idx = 187
wrdata C:/Users/udhav/DVD-Project/work/comp_pmos_off_10.out idx i(Vd) i(Vg) i(Vs) i(Vb) @m1[id] @m1[igs] @m1[igd] @m1[igcs] @m1[igcd] @m1[igb] @m1[igidl] @m1[igisl] @m1[isub] @m1[ibd] @m1[ibs]
destroy all
altermod pmos vth0=-4.408052254e-01
altermod pmos toxe=9.533374307e-10
altermod pmos ndep=5.121300485e+18
altermod pmos u0=5.733188468e-03
altermod pmos xj=5.317111934e-09
alter m1 w=6.777887739e-08
alter vd dc=4.937089593e-02
alter vg dc=1.006785218e+00
alter vs dc=4.050122517e-01
alter vb dc=1.006785218e+00
option temp=64.805804
op
let idx = 188
wrdata C:/Users/udhav/DVD-Project/work/comp_pmos_off_10.out idx i(Vd) i(Vg) i(Vs) i(Vb) @m1[id] @m1[igs] @m1[igd] @m1[igcs] @m1[igcd] @m1[igb] @m1[igidl] @m1[igisl] @m1[isub] @m1[ibd] @m1[ibs]
destroy all
altermod pmos vth0=-3.995182046e-01
altermod pmos toxe=9.824277654e-10
altermod pmos ndep=5.697346589e+18
altermod pmos u0=5.744240858e-03
altermod pmos xj=4.875169680e-09
alter m1 w=1.016900108e-07
alter vd dc=1.243844212e-02
alter vg dc=9.537217005e-01
alter vs dc=4.753721437e-01
alter vb dc=9.537217005e-01
option temp=-34.888699
op
let idx = 189
wrdata C:/Users/udhav/DVD-Project/work/comp_pmos_off_10.out idx i(Vd) i(Vg) i(Vs) i(Vb) @m1[id] @m1[igs] @m1[igd] @m1[igcs] @m1[igcd] @m1[igb] @m1[igidl] @m1[igisl] @m1[isub] @m1[ibd] @m1[ibs]
destroy all
altermod pmos vth0=-4.728122063e-01
altermod pmos toxe=1.073626645e-09
altermod pmos ndep=5.356784377e+18
altermod pmos u0=6.519576400e-03
altermod pmos xj=4.720777328e-09
alter m1 w=5.447464325e-08
alter vd dc=5.868496162e-01
alter vg dc=9.161141953e-01
alter vs dc=8.019167341e-02
alter vb dc=9.161141953e-01
option temp=31.967430
op
let idx = 190
wrdata C:/Users/udhav/DVD-Project/work/comp_pmos_off_10.out idx i(Vd) i(Vg) i(Vs) i(Vb) @m1[id] @m1[igs] @m1[igd] @m1[igcs] @m1[igcd] @m1[igb] @m1[igidl] @m1[igisl] @m1[isub] @m1[ibd] @m1[ibs]
destroy all
altermod pmos vth0=-3.984078443e-01
altermod pmos toxe=9.864669266e-10
altermod pmos ndep=5.473634799e+18
altermod pmos u0=6.416320539e-03
altermod pmos xj=4.698337615e-09
alter m1 w=1.214480069e-07
alter vd dc=2.501100617e-01
alter vg dc=1.022173373e+00
alter vs dc=6.531826578e-01
alter vb dc=1.022173373e+00
option temp=19.667594
op
let idx = 191
wrdata C:/Users/udhav/DVD-Project/work/comp_pmos_off_10.out idx i(Vd) i(Vg) i(Vs) i(Vb) @m1[id] @m1[igs] @m1[igd] @m1[igcs] @m1[igcd] @m1[igb] @m1[igidl] @m1[igisl] @m1[isub] @m1[ibd] @m1[ibs]
destroy all
altermod pmos vth0=-3.885309038e-01
altermod pmos toxe=1.085206453e-09
altermod pmos ndep=5.860600956e+18
altermod pmos u0=6.437132725e-03
altermod pmos xj=4.975528861e-09
alter m1 w=5.439173134e-08
alter vd dc=2.934878236e-01
alter vg dc=1.068204299e+00
alter vs dc=9.087692453e-01
alter vb dc=1.068204299e+00
option temp=17.017053
op
let idx = 192
wrdata C:/Users/udhav/DVD-Project/work/comp_pmos_off_10.out idx i(Vd) i(Vg) i(Vs) i(Vb) @m1[id] @m1[igs] @m1[igd] @m1[igcs] @m1[igcd] @m1[igb] @m1[igidl] @m1[igisl] @m1[isub] @m1[ibd] @m1[ibs]
destroy all
altermod pmos vth0=-3.922993868e-01
altermod pmos toxe=1.042435265e-09
altermod pmos ndep=5.079956530e+18
altermod pmos u0=6.418662283e-03
altermod pmos xj=5.361611493e-09
alter m1 w=7.032410686e-08
alter vd dc=1.915555893e-01
alter vg dc=9.074805343e-01
alter vs dc=1.922546700e-01
alter vb dc=9.074805343e-01
option temp=-13.518997
op
let idx = 193
wrdata C:/Users/udhav/DVD-Project/work/comp_pmos_off_10.out idx i(Vd) i(Vg) i(Vs) i(Vb) @m1[id] @m1[igs] @m1[igd] @m1[igcs] @m1[igcd] @m1[igb] @m1[igidl] @m1[igisl] @m1[isub] @m1[ibd] @m1[ibs]
destroy all
altermod pmos vth0=-4.591270968e-01
altermod pmos toxe=9.763446309e-10
altermod pmos ndep=5.083602854e+18
altermod pmos u0=6.270425468e-03
altermod pmos xj=4.910015971e-09
alter m1 w=3.151660950e-08
alter vd dc=1.576487124e-01
alter vg dc=9.243956546e-01
alter vs dc=7.975558101e-01
alter vb dc=9.243956546e-01
option temp=-39.119298
op
let idx = 194
wrdata C:/Users/udhav/DVD-Project/work/comp_pmos_off_10.out idx i(Vd) i(Vg) i(Vs) i(Vb) @m1[id] @m1[igs] @m1[igd] @m1[igcs] @m1[igcd] @m1[igb] @m1[igidl] @m1[igisl] @m1[isub] @m1[ibd] @m1[ibs]
destroy all
altermod pmos vth0=-4.169406494e-01
altermod pmos toxe=9.341491658e-10
altermod pmos ndep=5.848802224e+18
altermod pmos u0=5.617790392e-03
altermod pmos xj=4.885810058e-09
alter m1 w=1.193220070e-07
alter vd dc=6.677498118e-01
alter vg dc=9.044584927e-01
alter vs dc=7.146847379e-01
alter vb dc=9.044584927e-01
option temp=29.651961
op
let idx = 195
wrdata C:/Users/udhav/DVD-Project/work/comp_pmos_off_10.out idx i(Vd) i(Vg) i(Vs) i(Vb) @m1[id] @m1[igs] @m1[igd] @m1[igcs] @m1[igcd] @m1[igb] @m1[igidl] @m1[igisl] @m1[isub] @m1[ibd] @m1[ibs]
destroy all
altermod pmos vth0=-4.361809345e-01
altermod pmos toxe=1.078214932e-09
altermod pmos ndep=5.123885148e+18
altermod pmos u0=5.498552126e-03
altermod pmos xj=5.029337434e-09
alter m1 w=5.756444329e-08
alter vd dc=8.024520640e-01
alter vg dc=9.629141951e-01
alter vs dc=2.387284557e-01
alter vb dc=9.629141951e-01
option temp=-35.575089
op
let idx = 196
wrdata C:/Users/udhav/DVD-Project/work/comp_pmos_off_10.out idx i(Vd) i(Vg) i(Vs) i(Vb) @m1[id] @m1[igs] @m1[igd] @m1[igcs] @m1[igcd] @m1[igb] @m1[igidl] @m1[igisl] @m1[isub] @m1[ibd] @m1[ibs]
destroy all
altermod pmos vth0=-4.555853290e-01
altermod pmos toxe=9.307239608e-10
altermod pmos ndep=5.650651156e+18
altermod pmos u0=5.483219038e-03
altermod pmos xj=5.465088034e-09
alter m1 w=1.181673412e-07
alter vd dc=7.030142543e-01
alter vg dc=9.456698157e-01
alter vs dc=6.094658298e-01
alter vb dc=9.456698157e-01
option temp=67.672176
op
let idx = 197
wrdata C:/Users/udhav/DVD-Project/work/comp_pmos_off_10.out idx i(Vd) i(Vg) i(Vs) i(Vb) @m1[id] @m1[igs] @m1[igd] @m1[igcs] @m1[igcd] @m1[igb] @m1[igidl] @m1[igisl] @m1[isub] @m1[ibd] @m1[ibs]
destroy all
altermod pmos vth0=-4.221883707e-01
altermod pmos toxe=1.056903141e-09
altermod pmos ndep=5.600662973e+18
altermod pmos u0=5.463670085e-03
altermod pmos xj=4.578209076e-09
alter m1 w=8.413157678e-08
alter vd dc=1.443697432e-02
alter vg dc=1.028305048e+00
alter vs dc=6.851110627e-01
alter vb dc=1.028305048e+00
option temp=-31.173070
op
let idx = 198
wrdata C:/Users/udhav/DVD-Project/work/comp_pmos_off_10.out idx i(Vd) i(Vg) i(Vs) i(Vb) @m1[id] @m1[igs] @m1[igd] @m1[igcs] @m1[igcd] @m1[igb] @m1[igidl] @m1[igisl] @m1[isub] @m1[ibd] @m1[ibs]
destroy all
altermod pmos vth0=-4.297209787e-01
altermod pmos toxe=9.559709271e-10
altermod pmos ndep=5.998393830e+18
altermod pmos u0=6.239457247e-03
altermod pmos xj=4.697627364e-09
alter m1 w=1.208754959e-07
alter vd dc=9.423601944e-01
alter vg dc=1.062880079e+00
alter vs dc=6.059480635e-01
alter vb dc=1.062880079e+00
option temp=15.089722
op
let idx = 199
wrdata C:/Users/udhav/DVD-Project/work/comp_pmos_off_10.out idx i(Vd) i(Vg) i(Vs) i(Vb) @m1[id] @m1[igs] @m1[igd] @m1[igcs] @m1[igcd] @m1[igb] @m1[igidl] @m1[igisl] @m1[isub] @m1[ibd] @m1[ibs]
destroy all
altermod pmos vth0=-4.101640292e-01
altermod pmos toxe=1.031195511e-09
altermod pmos ndep=5.599131769e+18
altermod pmos u0=5.438937587e-03
altermod pmos xj=5.283673005e-09
alter m1 w=1.211015137e-07
alter vd dc=2.160586615e-01
alter vg dc=9.135510014e-01
alter vs dc=7.822300500e-01
alter vb dc=9.135510014e-01
option temp=14.879225
op
let idx = 200
wrdata C:/Users/udhav/DVD-Project/work/comp_pmos_off_10.out idx i(Vd) i(Vg) i(Vs) i(Vb) @m1[id] @m1[igs] @m1[igd] @m1[igcs] @m1[igcd] @m1[igb] @m1[igidl] @m1[igisl] @m1[isub] @m1[ibd] @m1[ibs]
destroy all
altermod pmos vth0=-3.970096859e-01
altermod pmos toxe=9.959918563e-10
altermod pmos ndep=5.641379514e+18
altermod pmos u0=6.070302933e-03
altermod pmos xj=5.041910548e-09
alter m1 w=9.188462989e-08
alter vd dc=2.373145546e-01
alter vg dc=1.094943840e+00
alter vs dc=4.000361059e-01
alter vb dc=1.094943840e+00
option temp=78.735018
op
let idx = 201
wrdata C:/Users/udhav/DVD-Project/work/comp_pmos_off_10.out idx i(Vd) i(Vg) i(Vs) i(Vb) @m1[id] @m1[igs] @m1[igd] @m1[igcs] @m1[igcd] @m1[igb] @m1[igidl] @m1[igisl] @m1[isub] @m1[ibd] @m1[ibs]
destroy all
altermod pmos vth0=-4.365297634e-01
altermod pmos toxe=1.034138167e-09
altermod pmos ndep=5.748171841e+18
altermod pmos u0=6.174373583e-03
altermod pmos xj=5.298867846e-09
alter m1 w=2.593849071e-08
alter vd dc=7.446657535e-01
alter vg dc=1.051513118e+00
alter vs dc=7.260292031e-01
alter vb dc=1.051513118e+00
option temp=92.908220
op
let idx = 202
wrdata C:/Users/udhav/DVD-Project/work/comp_pmos_off_10.out idx i(Vd) i(Vg) i(Vs) i(Vb) @m1[id] @m1[igs] @m1[igd] @m1[igcs] @m1[igcd] @m1[igb] @m1[igidl] @m1[igisl] @m1[isub] @m1[ibd] @m1[ibs]
destroy all
altermod pmos vth0=-4.387377048e-01
altermod pmos toxe=9.124664877e-10
altermod pmos ndep=5.986596149e+18
altermod pmos u0=6.154807729e-03
altermod pmos xj=5.218309853e-09
alter m1 w=7.108066514e-08
alter vd dc=4.693408311e-01
alter vg dc=1.023466162e+00
alter vs dc=8.242049385e-01
alter vb dc=1.023466162e+00
option temp=-10.938353
op
let idx = 203
wrdata C:/Users/udhav/DVD-Project/work/comp_pmos_off_10.out idx i(Vd) i(Vg) i(Vs) i(Vb) @m1[id] @m1[igs] @m1[igd] @m1[igcs] @m1[igcd] @m1[igb] @m1[igidl] @m1[igisl] @m1[isub] @m1[ibd] @m1[ibs]
destroy all
altermod pmos vth0=-3.922576483e-01
altermod pmos toxe=9.490995422e-10
altermod pmos ndep=5.793437666e+18
altermod pmos u0=5.695412525e-03
altermod pmos xj=4.571146036e-09
alter m1 w=7.661195715e-08
alter vd dc=8.555485563e-01
alter vg dc=1.011099929e+00
alter vs dc=6.700587126e-01
alter vb dc=1.011099929e+00
option temp=66.616863
op
let idx = 204
wrdata C:/Users/udhav/DVD-Project/work/comp_pmos_off_10.out idx i(Vd) i(Vg) i(Vs) i(Vb) @m1[id] @m1[igs] @m1[igd] @m1[igcs] @m1[igcd] @m1[igb] @m1[igidl] @m1[igisl] @m1[isub] @m1[ibd] @m1[ibs]
destroy all
altermod pmos vth0=-4.385831626e-01
altermod pmos toxe=1.048209961e-09
altermod pmos ndep=5.184438800e+18
altermod pmos u0=6.515689454e-03
altermod pmos xj=5.318549051e-09
alter m1 w=7.203653460e-08
alter vd dc=1.416590953e-01
alter vg dc=9.585003865e-01
alter vs dc=8.848949298e-01
alter vb dc=9.585003865e-01
option temp=7.630955
op
let idx = 205
wrdata C:/Users/udhav/DVD-Project/work/comp_pmos_off_10.out idx i(Vd) i(Vg) i(Vs) i(Vb) @m1[id] @m1[igs] @m1[igd] @m1[igcs] @m1[igcd] @m1[igb] @m1[igidl] @m1[igisl] @m1[isub] @m1[ibd] @m1[ibs]
destroy all
altermod pmos vth0=-4.452929693e-01
altermod pmos toxe=1.057412260e-09
altermod pmos ndep=5.661263540e+18
altermod pmos u0=6.337327503e-03
altermod pmos xj=4.555823012e-09
alter m1 w=9.317110868e-08
alter vd dc=9.140134670e-01
alter vg dc=9.301553551e-01
alter vs dc=5.126248817e-01
alter vb dc=9.301553551e-01
option temp=59.373190
op
let idx = 206
wrdata C:/Users/udhav/DVD-Project/work/comp_pmos_off_10.out idx i(Vd) i(Vg) i(Vs) i(Vb) @m1[id] @m1[igs] @m1[igd] @m1[igcs] @m1[igcd] @m1[igb] @m1[igidl] @m1[igisl] @m1[isub] @m1[ibd] @m1[ibs]
destroy all
altermod pmos vth0=-4.345128913e-01
altermod pmos toxe=1.085500822e-09
altermod pmos ndep=5.956755141e+18
altermod pmos u0=5.786647263e-03
altermod pmos xj=5.030457124e-09
alter m1 w=1.273568642e-07
alter vd dc=2.606036211e-01
alter vg dc=1.033078460e+00
alter vs dc=9.537300852e-01
alter vb dc=1.033078460e+00
option temp=85.027151
op
let idx = 207
wrdata C:/Users/udhav/DVD-Project/work/comp_pmos_off_10.out idx i(Vd) i(Vg) i(Vs) i(Vb) @m1[id] @m1[igs] @m1[igd] @m1[igcs] @m1[igcd] @m1[igb] @m1[igidl] @m1[igisl] @m1[isub] @m1[ibd] @m1[ibs]
destroy all
altermod pmos vth0=-4.523435472e-01
altermod pmos toxe=9.208491846e-10
altermod pmos ndep=5.967416729e+18
altermod pmos u0=5.570772200e-03
altermod pmos xj=5.446031047e-09
alter m1 w=5.299419082e-08
alter vd dc=1.886559784e-01
alter vg dc=1.047885533e+00
alter vs dc=3.070095522e-01
alter vb dc=1.047885533e+00
option temp=-29.361860
op
let idx = 208
wrdata C:/Users/udhav/DVD-Project/work/comp_pmos_off_10.out idx i(Vd) i(Vg) i(Vs) i(Vb) @m1[id] @m1[igs] @m1[igd] @m1[igcs] @m1[igcd] @m1[igb] @m1[igidl] @m1[igisl] @m1[isub] @m1[ibd] @m1[ibs]
destroy all
altermod pmos vth0=-4.011946960e-01
altermod pmos toxe=1.088627722e-09
altermod pmos ndep=6.004215688e+18
altermod pmos u0=6.110774639e-03
altermod pmos xj=5.125255109e-09
alter m1 w=7.960810790e-08
alter vd dc=6.566302655e-01
alter vg dc=1.025776983e+00
alter vs dc=9.769274430e-01
alter vb dc=1.025776983e+00
option temp=27.520731
op
let idx = 209
wrdata C:/Users/udhav/DVD-Project/work/comp_pmos_off_10.out idx i(Vd) i(Vg) i(Vs) i(Vb) @m1[id] @m1[igs] @m1[igd] @m1[igcs] @m1[igcd] @m1[igb] @m1[igidl] @m1[igisl] @m1[isub] @m1[ibd] @m1[ibs]
destroy all
altermod pmos vth0=-4.370455425e-01
altermod pmos toxe=9.804740383e-10
altermod pmos ndep=5.398120547e+18
altermod pmos u0=6.532802483e-03
altermod pmos xj=5.496430226e-09
alter m1 w=6.623356796e-08
alter vd dc=4.164310030e-01
alter vg dc=9.582730499e-01
alter vs dc=8.854227595e-01
alter vb dc=9.582730499e-01
option temp=-25.566126
op
let idx = 210
wrdata C:/Users/udhav/DVD-Project/work/comp_pmos_off_10.out idx i(Vd) i(Vg) i(Vs) i(Vb) @m1[id] @m1[igs] @m1[igd] @m1[igcs] @m1[igcd] @m1[igb] @m1[igidl] @m1[igisl] @m1[isub] @m1[ibd] @m1[ibs]
destroy all
altermod pmos vth0=-4.360862737e-01
altermod pmos toxe=9.804093023e-10
altermod pmos ndep=5.859083180e+18
altermod pmos u0=5.753796170e-03
altermod pmos xj=5.478354990e-09
alter m1 w=9.571491304e-08
alter vd dc=9.462800367e-01
alter vg dc=9.839493744e-01
alter vs dc=5.605440134e-01
alter vb dc=9.839493744e-01
option temp=23.063471
op
let idx = 211
wrdata C:/Users/udhav/DVD-Project/work/comp_pmos_off_10.out idx i(Vd) i(Vg) i(Vs) i(Vb) @m1[id] @m1[igs] @m1[igd] @m1[igcs] @m1[igcd] @m1[igb] @m1[igidl] @m1[igisl] @m1[isub] @m1[ibd] @m1[ibs]
destroy all
altermod pmos vth0=-4.036398780e-01
altermod pmos toxe=9.462951440e-10
altermod pmos ndep=5.597465957e+18
altermod pmos u0=6.107926331e-03
altermod pmos xj=4.618563758e-09
alter m1 w=5.544381018e-08
alter vd dc=5.452804467e-01
alter vg dc=9.226955756e-01
alter vs dc=4.746052352e-01
alter vb dc=9.226955756e-01
option temp=58.497075
op
let idx = 212
wrdata C:/Users/udhav/DVD-Project/work/comp_pmos_off_10.out idx i(Vd) i(Vg) i(Vs) i(Vb) @m1[id] @m1[igs] @m1[igd] @m1[igcs] @m1[igcd] @m1[igb] @m1[igidl] @m1[igisl] @m1[isub] @m1[ibd] @m1[ibs]
destroy all
altermod pmos vth0=-4.588152490e-01
altermod pmos toxe=9.124795323e-10
altermod pmos ndep=5.385295303e+18
altermod pmos u0=5.738425404e-03
altermod pmos xj=5.086131085e-09
alter m1 w=8.584709117e-08
alter vd dc=2.656372383e-01
alter vg dc=9.534477170e-01
alter vs dc=3.080359412e-01
alter vb dc=9.534477170e-01
option temp=-1.320257
op
let idx = 213
wrdata C:/Users/udhav/DVD-Project/work/comp_pmos_off_10.out idx i(Vd) i(Vg) i(Vs) i(Vb) @m1[id] @m1[igs] @m1[igd] @m1[igcs] @m1[igcd] @m1[igb] @m1[igidl] @m1[igisl] @m1[isub] @m1[ibd] @m1[ibs]
destroy all
altermod pmos vth0=-4.327629300e-01
altermod pmos toxe=9.780342665e-10
altermod pmos ndep=5.702682528e+18
altermod pmos u0=5.816484349e-03
altermod pmos xj=4.507413619e-09
alter m1 w=4.497812024e-08
alter vd dc=3.778326715e-01
alter vg dc=1.001752258e+00
alter vs dc=9.173321532e-01
alter vb dc=1.001752258e+00
option temp=21.370666
op
let idx = 214
wrdata C:/Users/udhav/DVD-Project/work/comp_pmos_off_10.out idx i(Vd) i(Vg) i(Vs) i(Vb) @m1[id] @m1[igs] @m1[igd] @m1[igcs] @m1[igcd] @m1[igb] @m1[igidl] @m1[igisl] @m1[isub] @m1[ibd] @m1[ibs]
destroy all
altermod pmos vth0=-4.244988519e-01
altermod pmos toxe=9.910422538e-10
altermod pmos ndep=5.569155629e+18
altermod pmos u0=6.488217133e-03
altermod pmos xj=4.530701705e-09
alter m1 w=2.094001383e-08
alter vd dc=8.118642414e-01
alter vg dc=9.953851740e-01
alter vs dc=8.819161256e-01
alter vb dc=9.953851740e-01
option temp=111.079115
op
let idx = 215
wrdata C:/Users/udhav/DVD-Project/work/comp_pmos_off_10.out idx i(Vd) i(Vg) i(Vs) i(Vb) @m1[id] @m1[igs] @m1[igd] @m1[igcs] @m1[igcd] @m1[igb] @m1[igidl] @m1[igisl] @m1[isub] @m1[ibd] @m1[ibs]
destroy all
altermod pmos vth0=-4.408204488e-01
altermod pmos toxe=1.062783116e-09
altermod pmos ndep=5.575486212e+18
altermod pmos u0=5.831599760e-03
altermod pmos xj=4.520063713e-09
alter m1 w=5.938029072e-08
alter vd dc=3.067588621e-01
alter vg dc=1.050608559e+00
alter vs dc=5.320382736e-01
alter vb dc=1.050608559e+00
option temp=71.242368
op
let idx = 216
wrdata C:/Users/udhav/DVD-Project/work/comp_pmos_off_10.out idx i(Vd) i(Vg) i(Vs) i(Vb) @m1[id] @m1[igs] @m1[igd] @m1[igcs] @m1[igcd] @m1[igb] @m1[igidl] @m1[igisl] @m1[isub] @m1[ibd] @m1[ibs]
destroy all
altermod pmos vth0=-4.230682497e-01
altermod pmos toxe=1.087515365e-09
altermod pmos ndep=5.956229812e+18
altermod pmos u0=6.096311821e-03
altermod pmos xj=5.414419281e-09
alter m1 w=3.362777660e-08
alter vd dc=7.682324350e-01
alter vg dc=9.251913181e-01
alter vs dc=4.995509913e-01
alter vb dc=9.251913181e-01
option temp=4.965542
op
let idx = 217
wrdata C:/Users/udhav/DVD-Project/work/comp_pmos_off_10.out idx i(Vd) i(Vg) i(Vs) i(Vb) @m1[id] @m1[igs] @m1[igd] @m1[igcs] @m1[igcd] @m1[igb] @m1[igidl] @m1[igisl] @m1[isub] @m1[ibd] @m1[ibs]
destroy all
altermod pmos vth0=-4.288197829e-01
altermod pmos toxe=9.818132991e-10
altermod pmos ndep=5.006878247e+18
altermod pmos u0=6.520807683e-03
altermod pmos xj=5.087873336e-09
alter m1 w=2.212818157e-08
alter vd dc=5.443492781e-01
alter vg dc=1.060775479e+00
alter vs dc=4.283885110e-02
alter vb dc=1.060775479e+00
option temp=-34.635325
op
let idx = 218
wrdata C:/Users/udhav/DVD-Project/work/comp_pmos_off_10.out idx i(Vd) i(Vg) i(Vs) i(Vb) @m1[id] @m1[igs] @m1[igd] @m1[igcs] @m1[igcd] @m1[igb] @m1[igidl] @m1[igisl] @m1[isub] @m1[ibd] @m1[ibs]
destroy all
altermod pmos vth0=-4.203017407e-01
altermod pmos toxe=1.049224427e-09
altermod pmos ndep=5.531662833e+18
altermod pmos u0=6.491680963e-03
altermod pmos xj=5.020649507e-09
alter m1 w=2.837863990e-08
alter vd dc=6.200774854e-01
alter vg dc=1.085307643e+00
alter vs dc=6.531851520e-01
alter vb dc=1.085307643e+00
option temp=99.344796
op
let idx = 219
wrdata C:/Users/udhav/DVD-Project/work/comp_pmos_off_10.out idx i(Vd) i(Vg) i(Vs) i(Vb) @m1[id] @m1[igs] @m1[igd] @m1[igcs] @m1[igcd] @m1[igb] @m1[igidl] @m1[igisl] @m1[isub] @m1[ibd] @m1[ibs]
destroy all
altermod pmos vth0=-4.559297339e-01
altermod pmos toxe=1.084333447e-09
altermod pmos ndep=5.820394454e+18
altermod pmos u0=6.482694086e-03
altermod pmos xj=5.400219388e-09
alter m1 w=1.137754021e-07
alter vd dc=2.298407956e-01
alter vg dc=9.529563642e-01
alter vs dc=5.985645136e-01
alter vb dc=9.529563642e-01
option temp=6.253823
op
let idx = 220
wrdata C:/Users/udhav/DVD-Project/work/comp_pmos_off_10.out idx i(Vd) i(Vg) i(Vs) i(Vb) @m1[id] @m1[igs] @m1[igd] @m1[igcs] @m1[igcd] @m1[igb] @m1[igidl] @m1[igisl] @m1[isub] @m1[ibd] @m1[ibs]
destroy all
altermod pmos vth0=-4.650184039e-01
altermod pmos toxe=9.838928547e-10
altermod pmos ndep=5.333744002e+18
altermod pmos u0=6.337668435e-03
altermod pmos xj=4.593256481e-09
alter m1 w=9.099057832e-08
alter vd dc=9.371169232e-01
alter vg dc=9.387696684e-01
alter vs dc=3.809721857e-02
alter vb dc=9.387696684e-01
option temp=-18.444210
op
let idx = 221
wrdata C:/Users/udhav/DVD-Project/work/comp_pmos_off_10.out idx i(Vd) i(Vg) i(Vs) i(Vb) @m1[id] @m1[igs] @m1[igd] @m1[igcs] @m1[igcd] @m1[igb] @m1[igidl] @m1[igisl] @m1[isub] @m1[ibd] @m1[ibs]
destroy all
altermod pmos vth0=-4.535122734e-01
altermod pmos toxe=1.060171716e-09
altermod pmos ndep=4.981410649e+18
altermod pmos u0=6.503749650e-03
altermod pmos xj=4.888394608e-09
alter m1 w=5.692987475e-08
alter vd dc=8.168554389e-01
alter vg dc=1.022962131e+00
alter vs dc=5.211855944e-01
alter vb dc=1.022962131e+00
option temp=-17.622235
op
let idx = 222
wrdata C:/Users/udhav/DVD-Project/work/comp_pmos_off_10.out idx i(Vd) i(Vg) i(Vs) i(Vb) @m1[id] @m1[igs] @m1[igd] @m1[igcs] @m1[igcd] @m1[igb] @m1[igidl] @m1[igisl] @m1[isub] @m1[ibd] @m1[ibs]
destroy all
altermod pmos vth0=-4.381446419e-01
altermod pmos toxe=1.017096531e-09
altermod pmos ndep=5.746844442e+18
altermod pmos u0=6.329548734e-03
altermod pmos xj=4.976990738e-09
alter m1 w=4.161344431e-08
alter vd dc=2.424656563e-01
alter vg dc=9.876596552e-01
alter vs dc=3.894453447e-01
alter vb dc=9.876596552e-01
option temp=50.586607
op
let idx = 223
wrdata C:/Users/udhav/DVD-Project/work/comp_pmos_off_10.out idx i(Vd) i(Vg) i(Vs) i(Vb) @m1[id] @m1[igs] @m1[igd] @m1[igcs] @m1[igcd] @m1[igb] @m1[igidl] @m1[igisl] @m1[isub] @m1[ibd] @m1[ibs]
destroy all
altermod pmos vth0=-4.201953955e-01
altermod pmos toxe=1.037266535e-09
altermod pmos ndep=5.398942768e+18
altermod pmos u0=6.568316900e-03
altermod pmos xj=5.184630085e-09
alter m1 w=1.245334049e-07
alter vd dc=6.269112698e-01
alter vg dc=1.066214858e+00
alter vs dc=8.882366661e-01
alter vb dc=1.066214858e+00
option temp=109.670644
op
let idx = 224
wrdata C:/Users/udhav/DVD-Project/work/comp_pmos_off_10.out idx i(Vd) i(Vg) i(Vs) i(Vb) @m1[id] @m1[igs] @m1[igd] @m1[igcs] @m1[igcd] @m1[igb] @m1[igidl] @m1[igisl] @m1[isub] @m1[ibd] @m1[ibs]
destroy all
altermod pmos vth0=-4.323946347e-01
altermod pmos toxe=9.893547474e-10
altermod pmos ndep=5.623780061e+18
altermod pmos u0=6.341244380e-03
altermod pmos xj=5.111331003e-09
alter m1 w=8.457975509e-08
alter vd dc=3.208491403e-01
alter vg dc=9.112966431e-01
alter vs dc=8.925851512e-01
alter vb dc=9.112966431e-01
option temp=106.426663
op
let idx = 225
wrdata C:/Users/udhav/DVD-Project/work/comp_pmos_off_10.out idx i(Vd) i(Vg) i(Vs) i(Vb) @m1[id] @m1[igs] @m1[igd] @m1[igcs] @m1[igcd] @m1[igb] @m1[igidl] @m1[igisl] @m1[isub] @m1[ibd] @m1[ibs]
destroy all
altermod pmos vth0=-4.229884515e-01
altermod pmos toxe=9.938213506e-10
altermod pmos ndep=5.490249375e+18
altermod pmos u0=5.536531105e-03
altermod pmos xj=4.911038246e-09
alter m1 w=6.288141966e-08
alter vd dc=2.930950408e-01
alter vg dc=1.042071311e+00
alter vs dc=5.834693261e-01
alter vb dc=1.042071311e+00
option temp=-11.325347
op
let idx = 226
wrdata C:/Users/udhav/DVD-Project/work/comp_pmos_off_10.out idx i(Vd) i(Vg) i(Vs) i(Vb) @m1[id] @m1[igs] @m1[igd] @m1[igcs] @m1[igcd] @m1[igb] @m1[igidl] @m1[igisl] @m1[isub] @m1[ibd] @m1[ibs]
destroy all
altermod pmos vth0=-4.369678590e-01
altermod pmos toxe=9.107084565e-10
altermod pmos ndep=5.410947464e+18
altermod pmos u0=5.557811485e-03
altermod pmos xj=4.931068608e-09
alter m1 w=8.772031767e-08
alter vd dc=9.193934950e-02
alter vg dc=9.792291599e-01
alter vs dc=9.134809346e-01
alter vb dc=9.792291599e-01
option temp=97.446556
op
let idx = 227
wrdata C:/Users/udhav/DVD-Project/work/comp_pmos_off_10.out idx i(Vd) i(Vg) i(Vs) i(Vb) @m1[id] @m1[igs] @m1[igd] @m1[igcs] @m1[igcd] @m1[igb] @m1[igidl] @m1[igisl] @m1[isub] @m1[ibd] @m1[ibs]
destroy all
altermod pmos vth0=-4.522597615e-01
altermod pmos toxe=9.302015918e-10
altermod pmos ndep=5.971430463e+18
altermod pmos u0=6.316798876e-03
altermod pmos xj=5.426987887e-09
alter m1 w=1.058581954e-07
alter vd dc=3.192806455e-01
alter vg dc=9.334155092e-01
alter vs dc=6.909815283e-01
alter vb dc=9.334155092e-01
option temp=102.569699
op
let idx = 228
wrdata C:/Users/udhav/DVD-Project/work/comp_pmos_off_10.out idx i(Vd) i(Vg) i(Vs) i(Vb) @m1[id] @m1[igs] @m1[igd] @m1[igcs] @m1[igcd] @m1[igb] @m1[igidl] @m1[igisl] @m1[isub] @m1[ibd] @m1[ibs]
destroy all
altermod pmos vth0=-4.742047947e-01
altermod pmos toxe=9.915563420e-10
altermod pmos ndep=5.894419207e+18
altermod pmos u0=6.401767661e-03
altermod pmos xj=4.507455193e-09
alter m1 w=1.004046049e-07
alter vd dc=1.308063532e-02
alter vg dc=1.044283544e+00
alter vs dc=1.649286031e-01
alter vb dc=1.044283544e+00
option temp=115.332229
op
let idx = 229
wrdata C:/Users/udhav/DVD-Project/work/comp_pmos_off_10.out idx i(Vd) i(Vg) i(Vs) i(Vb) @m1[id] @m1[igs] @m1[igd] @m1[igcs] @m1[igcd] @m1[igb] @m1[igidl] @m1[igisl] @m1[isub] @m1[ibd] @m1[ibs]
destroy all
altermod pmos vth0=-4.564556226e-01
altermod pmos toxe=1.028743540e-09
altermod pmos ndep=5.672416672e+18
altermod pmos u0=6.291531149e-03
altermod pmos xj=5.278010893e-09
alter m1 w=2.323693910e-08
alter vd dc=5.307670807e-01
alter vg dc=9.024040344e-01
alter vs dc=8.718962281e-01
alter vb dc=9.024040344e-01
option temp=96.877505
op
let idx = 230
wrdata C:/Users/udhav/DVD-Project/work/comp_pmos_off_10.out idx i(Vd) i(Vg) i(Vs) i(Vb) @m1[id] @m1[igs] @m1[igd] @m1[igcs] @m1[igcd] @m1[igb] @m1[igidl] @m1[igisl] @m1[isub] @m1[ibd] @m1[ibs]
destroy all
altermod pmos vth0=-4.118020568e-01
altermod pmos toxe=1.027628645e-09
altermod pmos ndep=5.671384263e+18
altermod pmos u0=6.197518766e-03
altermod pmos xj=4.867817535e-09
alter m1 w=9.796151288e-08
alter vd dc=9.843709128e-01
alter vg dc=1.034765383e+00
alter vs dc=4.536470018e-01
alter vb dc=1.034765383e+00
option temp=14.078162
op
let idx = 231
wrdata C:/Users/udhav/DVD-Project/work/comp_pmos_off_10.out idx i(Vd) i(Vg) i(Vs) i(Vb) @m1[id] @m1[igs] @m1[igd] @m1[igcs] @m1[igcd] @m1[igb] @m1[igidl] @m1[igisl] @m1[isub] @m1[ibd] @m1[ibs]
destroy all
altermod pmos vth0=-4.287119736e-01
altermod pmos toxe=9.945841661e-10
altermod pmos ndep=5.156333815e+18
altermod pmos u0=5.737783683e-03
altermod pmos xj=4.986151350e-09
alter m1 w=4.043107427e-08
alter vd dc=3.291047719e-01
alter vg dc=1.014443503e+00
alter vs dc=9.478143130e-01
alter vb dc=1.014443503e+00
option temp=-23.623854
op
let idx = 232
wrdata C:/Users/udhav/DVD-Project/work/comp_pmos_off_10.out idx i(Vd) i(Vg) i(Vs) i(Vb) @m1[id] @m1[igs] @m1[igd] @m1[igcs] @m1[igcd] @m1[igb] @m1[igidl] @m1[igisl] @m1[isub] @m1[ibd] @m1[ibs]
destroy all
altermod pmos vth0=-4.059612787e-01
altermod pmos toxe=9.492447282e-10
altermod pmos ndep=5.875533951e+18
altermod pmos u0=5.913164488e-03
altermod pmos xj=5.141014131e-09
alter m1 w=3.269644905e-08
alter vd dc=1.082318111e+00
alter vg dc=1.083698973e+00
alter vs dc=6.048852024e-01
alter vb dc=1.083698973e+00
option temp=50.364601
op
let idx = 233
wrdata C:/Users/udhav/DVD-Project/work/comp_pmos_off_10.out idx i(Vd) i(Vg) i(Vs) i(Vb) @m1[id] @m1[igs] @m1[igd] @m1[igcs] @m1[igcd] @m1[igb] @m1[igidl] @m1[igisl] @m1[isub] @m1[ibd] @m1[ibs]
destroy all
altermod pmos vth0=-3.896022953e-01
altermod pmos toxe=1.000884257e-09
altermod pmos ndep=5.720302573e+18
altermod pmos u0=6.396956043e-03
altermod pmos xj=5.006595912e-09
alter m1 w=1.089680991e-07
alter vd dc=5.829872730e-01
alter vg dc=1.088638329e+00
alter vs dc=6.576501670e-02
alter vb dc=1.088638329e+00
option temp=115.340779
op
let idx = 234
wrdata C:/Users/udhav/DVD-Project/work/comp_pmos_off_10.out idx i(Vd) i(Vg) i(Vs) i(Vb) @m1[id] @m1[igs] @m1[igd] @m1[igcs] @m1[igcd] @m1[igb] @m1[igidl] @m1[igisl] @m1[isub] @m1[ibd] @m1[ibs]
destroy all
altermod pmos vth0=-4.014440464e-01
altermod pmos toxe=9.781084816e-10
altermod pmos ndep=5.423961140e+18
altermod pmos u0=5.480734529e-03
altermod pmos xj=4.788360304e-09
alter m1 w=1.079620330e-07
alter vd dc=3.601812444e-01
alter vg dc=9.140137857e-01
alter vs dc=4.508869115e-02
alter vb dc=9.140137857e-01
option temp=37.290708
op
let idx = 235
wrdata C:/Users/udhav/DVD-Project/work/comp_pmos_off_10.out idx i(Vd) i(Vg) i(Vs) i(Vb) @m1[id] @m1[igs] @m1[igd] @m1[igcs] @m1[igcd] @m1[igb] @m1[igidl] @m1[igisl] @m1[isub] @m1[ibd] @m1[ibs]
destroy all
altermod pmos vth0=-4.556737470e-01
altermod pmos toxe=9.823978409e-10
altermod pmos ndep=5.455966027e+18
altermod pmos u0=6.425349758e-03
altermod pmos xj=4.926780544e-09
alter m1 w=9.114866577e-08
alter vd dc=1.457815738e-01
alter vg dc=1.081115015e+00
alter vs dc=6.428833563e-02
alter vb dc=1.081115015e+00
option temp=1.473774
op
let idx = 236
wrdata C:/Users/udhav/DVD-Project/work/comp_pmos_off_10.out idx i(Vd) i(Vg) i(Vs) i(Vb) @m1[id] @m1[igs] @m1[igd] @m1[igcs] @m1[igcd] @m1[igb] @m1[igidl] @m1[igisl] @m1[isub] @m1[ibd] @m1[ibs]
destroy all
altermod pmos vth0=-4.492984238e-01
altermod pmos toxe=9.169957823e-10
altermod pmos ndep=5.340202031e+18
altermod pmos u0=5.928386247e-03
altermod pmos xj=4.783623300e-09
alter m1 w=5.688443143e-08
alter vd dc=7.933765112e-02
alter vg dc=9.048824480e-01
alter vs dc=1.566217026e-02
alter vb dc=9.048824480e-01
option temp=99.398891
op
let idx = 237
wrdata C:/Users/udhav/DVD-Project/work/comp_pmos_off_10.out idx i(Vd) i(Vg) i(Vs) i(Vb) @m1[id] @m1[igs] @m1[igd] @m1[igcs] @m1[igcd] @m1[igb] @m1[igidl] @m1[igisl] @m1[isub] @m1[ibd] @m1[ibs]
destroy all
altermod pmos vth0=-3.906892298e-01
altermod pmos toxe=9.841460380e-10
altermod pmos ndep=5.806711058e+18
altermod pmos u0=6.211653988e-03
altermod pmos xj=4.555626919e-09
alter m1 w=3.392947541e-08
alter vd dc=3.901122907e-01
alter vg dc=9.712374051e-01
alter vs dc=2.251381818e-01
alter vb dc=9.712374051e-01
option temp=57.494624
op
let idx = 238
wrdata C:/Users/udhav/DVD-Project/work/comp_pmos_off_10.out idx i(Vd) i(Vg) i(Vs) i(Vb) @m1[id] @m1[igs] @m1[igd] @m1[igcs] @m1[igcd] @m1[igb] @m1[igidl] @m1[igisl] @m1[isub] @m1[ibd] @m1[ibs]
destroy all
altermod pmos vth0=-3.901726250e-01
altermod pmos toxe=9.964947220e-10
altermod pmos ndep=5.061649468e+18
altermod pmos u0=5.982005044e-03
altermod pmos xj=4.687681815e-09
alter m1 w=8.764166100e-08
alter vd dc=1.537450938e-01
alter vg dc=1.072256979e+00
alter vs dc=6.845167228e-01
alter vb dc=1.072256979e+00
option temp=56.904934
op
let idx = 239
wrdata C:/Users/udhav/DVD-Project/work/comp_pmos_off_10.out idx i(Vd) i(Vg) i(Vs) i(Vb) @m1[id] @m1[igs] @m1[igd] @m1[igcs] @m1[igcd] @m1[igb] @m1[igidl] @m1[igisl] @m1[isub] @m1[ibd] @m1[ibs]
destroy all
altermod pmos vth0=-4.683118606e-01
altermod pmos toxe=9.593382768e-10
altermod pmos ndep=5.063208393e+18
altermod pmos u0=6.433115620e-03
altermod pmos xj=5.383981738e-09
alter m1 w=5.837990844e-08
alter vd dc=6.493327799e-01
alter vg dc=9.735910141e-01
alter vs dc=6.057553537e-01
alter vb dc=9.735910141e-01
option temp=97.807277
op
let idx = 240
wrdata C:/Users/udhav/DVD-Project/work/comp_pmos_off_10.out idx i(Vd) i(Vg) i(Vs) i(Vb) @m1[id] @m1[igs] @m1[igd] @m1[igcs] @m1[igcd] @m1[igb] @m1[igidl] @m1[igisl] @m1[isub] @m1[ibd] @m1[ibs]
destroy all
altermod pmos vth0=-4.491753368e-01
altermod pmos toxe=9.845273049e-10
altermod pmos ndep=5.852005573e+18
altermod pmos u0=5.411880451e-03
altermod pmos xj=5.098334190e-09
alter m1 w=2.988782944e-08
alter vd dc=6.292406610e-01
alter vg dc=1.010458267e+00
alter vs dc=1.247696793e-01
alter vb dc=1.010458267e+00
option temp=86.848588
op
let idx = 241
wrdata C:/Users/udhav/DVD-Project/work/comp_pmos_off_10.out idx i(Vd) i(Vg) i(Vs) i(Vb) @m1[id] @m1[igs] @m1[igd] @m1[igcs] @m1[igcd] @m1[igb] @m1[igidl] @m1[igisl] @m1[isub] @m1[ibd] @m1[ibs]
destroy all
altermod pmos vth0=-4.713375198e-01
altermod pmos toxe=1.087603057e-09
altermod pmos ndep=5.345725147e+18
altermod pmos u0=6.516552613e-03
altermod pmos xj=5.296729423e-09
alter m1 w=1.195911519e-07
alter vd dc=8.816012744e-01
alter vg dc=1.026403827e+00
alter vs dc=5.595214962e-01
alter vb dc=1.026403827e+00
option temp=17.729442
op
let idx = 242
wrdata C:/Users/udhav/DVD-Project/work/comp_pmos_off_10.out idx i(Vd) i(Vg) i(Vs) i(Vb) @m1[id] @m1[igs] @m1[igd] @m1[igcs] @m1[igcd] @m1[igb] @m1[igidl] @m1[igisl] @m1[isub] @m1[ibd] @m1[ibs]
destroy all
altermod pmos vth0=-4.140243199e-01
altermod pmos toxe=1.010762847e-09
altermod pmos ndep=5.503635070e+18
altermod pmos u0=5.755190917e-03
altermod pmos xj=4.975030205e-09
alter m1 w=8.125039404e-08
alter vd dc=4.167803225e-01
alter vg dc=9.536436773e-01
alter vs dc=7.188711559e-01
alter vb dc=9.536436773e-01
option temp=-13.003189
op
let idx = 243
wrdata C:/Users/udhav/DVD-Project/work/comp_pmos_off_10.out idx i(Vd) i(Vg) i(Vs) i(Vb) @m1[id] @m1[igs] @m1[igd] @m1[igcs] @m1[igcd] @m1[igb] @m1[igidl] @m1[igisl] @m1[isub] @m1[ibd] @m1[ibs]
destroy all
altermod pmos vth0=-4.262335563e-01
altermod pmos toxe=1.074686830e-09
altermod pmos ndep=5.118122031e+18
altermod pmos u0=5.934446600e-03
altermod pmos xj=5.203700794e-09
alter m1 w=4.638264454e-08
alter vd dc=7.047643859e-01
alter vg dc=9.995329281e-01
alter vs dc=2.347754774e-01
alter vb dc=9.995329281e-01
option temp=123.067679
op
let idx = 244
wrdata C:/Users/udhav/DVD-Project/work/comp_pmos_off_10.out idx i(Vd) i(Vg) i(Vs) i(Vb) @m1[id] @m1[igs] @m1[igd] @m1[igcs] @m1[igcd] @m1[igb] @m1[igidl] @m1[igisl] @m1[isub] @m1[ibd] @m1[ibs]
destroy all
altermod pmos vth0=-4.461994992e-01
altermod pmos toxe=9.300576607e-10
altermod pmos ndep=5.354241310e+18
altermod pmos u0=6.293651607e-03
altermod pmos xj=4.838198893e-09
alter m1 w=8.652168694e-08
alter vd dc=2.436831807e-02
alter vg dc=9.241581702e-01
alter vs dc=4.238083555e-01
alter vb dc=9.241581702e-01
option temp=117.849044
op
let idx = 245
wrdata C:/Users/udhav/DVD-Project/work/comp_pmos_off_10.out idx i(Vd) i(Vg) i(Vs) i(Vb) @m1[id] @m1[igs] @m1[igd] @m1[igcs] @m1[igcd] @m1[igb] @m1[igidl] @m1[igisl] @m1[isub] @m1[ibd] @m1[ibs]
destroy all
altermod pmos vth0=-4.510038740e-01
altermod pmos toxe=1.058413906e-09
altermod pmos ndep=5.528527582e+18
altermod pmos u0=6.125221329e-03
altermod pmos xj=4.625274132e-09
alter m1 w=1.023780485e-07
alter vd dc=1.442648752e-01
alter vg dc=9.268396947e-01
alter vs dc=5.546383606e-01
alter vb dc=9.268396947e-01
option temp=-19.135825
op
let idx = 246
wrdata C:/Users/udhav/DVD-Project/work/comp_pmos_off_10.out idx i(Vd) i(Vg) i(Vs) i(Vb) @m1[id] @m1[igs] @m1[igd] @m1[igcs] @m1[igcd] @m1[igb] @m1[igidl] @m1[igisl] @m1[isub] @m1[ibd] @m1[ibs]
destroy all
altermod pmos vth0=-4.138110921e-01
altermod pmos toxe=9.272633881e-10
altermod pmos ndep=5.124677832e+18
altermod pmos u0=5.962078923e-03
altermod pmos xj=4.595989959e-09
alter m1 w=4.907700080e-08
alter vd dc=5.213384526e-01
alter vg dc=1.018247347e+00
alter vs dc=3.230634335e-01
alter vb dc=1.018247347e+00
option temp=91.871434
op
let idx = 247
wrdata C:/Users/udhav/DVD-Project/work/comp_pmos_off_10.out idx i(Vd) i(Vg) i(Vs) i(Vb) @m1[id] @m1[igs] @m1[igd] @m1[igcs] @m1[igcd] @m1[igb] @m1[igidl] @m1[igisl] @m1[isub] @m1[ibd] @m1[ibs]
destroy all
altermod pmos vth0=-4.203965154e-01
altermod pmos toxe=9.010987550e-10
altermod pmos ndep=4.955534944e+18
altermod pmos u0=6.300943466e-03
altermod pmos xj=4.788817481e-09
alter m1 w=2.700268101e-08
alter vd dc=2.491058441e-01
alter vg dc=1.045417091e+00
alter vs dc=2.446949927e-01
alter vb dc=1.045417091e+00
option temp=-38.036565
op
let idx = 248
wrdata C:/Users/udhav/DVD-Project/work/comp_pmos_off_10.out idx i(Vd) i(Vg) i(Vs) i(Vb) @m1[id] @m1[igs] @m1[igd] @m1[igcs] @m1[igcd] @m1[igb] @m1[igidl] @m1[igisl] @m1[isub] @m1[ibd] @m1[ibs]
destroy all
altermod pmos vth0=-4.514742009e-01
altermod pmos toxe=1.017917432e-09
altermod pmos ndep=5.277332388e+18
altermod pmos u0=6.097595743e-03
altermod pmos xj=5.495331016e-09
alter m1 w=6.798301965e-08
alter vd dc=7.009989447e-01
alter vg dc=9.709453036e-01
alter vs dc=5.554282553e-01
alter vb dc=9.709453036e-01
option temp=-38.304145
op
let idx = 249
wrdata C:/Users/udhav/DVD-Project/work/comp_pmos_off_10.out idx i(Vd) i(Vg) i(Vs) i(Vb) @m1[id] @m1[igs] @m1[igd] @m1[igcs] @m1[igcd] @m1[igb] @m1[igidl] @m1[igisl] @m1[isub] @m1[ibd] @m1[ibs]
destroy all
.endc
.end
