* or_AND2
.include C:/Users/udhav/DVD-Project/models/16nm_HP.pm
.options gmin=1e-18 abstol=1e-18 reltol=1e-6 vntol=1e-9
Vdd vdd 0 0
Va a 0 0
Vb b 0 0
Mnand20_MP_A g_nd a vdd vdd pmos W=6.400000000e-08 L=1.600000000e-08
Mnand20_MP_B g_nd b vdd vdd pmos W=6.400000000e-08 L=1.600000000e-08
Mnand20_MN_A g_nd a nand20_x 0 nmos W=3.200000000e-08 L=1.600000000e-08
Mnand20_MN_B nand20_x b 0 0 nmos W=3.200000000e-08 L=1.600000000e-08
Minv1_MP out g_nd vdd vdd pmos W=6.400000000e-08 L=1.600000000e-08
Minv1_MN out g_nd 0 0 nmos W=3.200000000e-08 L=1.600000000e-08
.control
set appendwrite
set wr_vecnames=0
altermod nmos vth0=5.242984801e-01
altermod nmos toxe=8.900117236e-10
altermod nmos ndep=7.548490843e+18
altermod nmos u0=3.011681022e-02
altermod nmos xj=5.436386654e-09
altermod pmos vth0=-4.605117861e-01
altermod pmos toxe=9.662249249e-10
altermod pmos ndep=5.214881135e+18
altermod pmos u0=6.025462890e-03
altermod pmos xj=5.274093749e-09
alter vdd dc=1.074710689e+00
alter va dc=1.074710689e+00
alter vb dc=1.074710689e+00
option temp=-33.451741
op
let idx = 0
wrdata C:/Users/udhav/DVD-Project/work/or_AND2_1.out idx i(Vdd) i(Va) i(Vb) v(g_nd) v(nand20_x) v(out)
destroy all
altermod nmos vth0=4.868808256e-01
altermod nmos toxe=9.127444255e-10
altermod nmos ndep=7.688797463e+18
altermod nmos u0=2.874371937e-02
altermod nmos xj=4.756128506e-09
altermod pmos vth0=-4.439258512e-01
altermod pmos toxe=9.122112104e-10
altermod pmos ndep=5.271089444e+18
altermod pmos u0=6.232100876e-03
altermod pmos xj=4.521598648e-09
alter vdd dc=9.010530609e-01
alter va dc=9.010530609e-01
alter vb dc=9.010530609e-01
option temp=92.274627
op
let idx = 1
wrdata C:/Users/udhav/DVD-Project/work/or_AND2_1.out idx i(Vdd) i(Va) i(Vb) v(g_nd) v(nand20_x) v(out)
destroy all
altermod nmos vth0=5.087807367e-01
altermod nmos toxe=9.400279876e-10
altermod nmos ndep=6.672458583e+18
altermod nmos u0=2.775528425e-02
altermod nmos xj=4.500656758e-09
altermod pmos vth0=-4.042207327e-01
altermod pmos toxe=9.812752731e-10
altermod pmos ndep=5.143301617e+18
altermod pmos u0=6.151760011e-03
altermod pmos xj=4.982660261e-09
alter vdd dc=1.064245684e+00
alter va dc=1.064245684e+00
alter vb dc=1.064245684e+00
option temp=118.411701
op
let idx = 2
wrdata C:/Users/udhav/DVD-Project/work/or_AND2_1.out idx i(Vdd) i(Va) i(Vb) v(g_nd) v(nand20_x) v(out)
destroy all
altermod nmos vth0=4.587298176e-01
altermod nmos toxe=1.031319350e-09
altermod nmos ndep=6.934113579e+18
altermod nmos u0=2.776914708e-02
altermod nmos xj=4.887605418e-09
altermod pmos vth0=-4.590667251e-01
altermod pmos toxe=9.897434551e-10
altermod pmos ndep=5.944843307e+18
altermod pmos u0=5.803573616e-03
altermod pmos xj=5.102806219e-09
alter vdd dc=1.059413886e+00
alter va dc=1.059413886e+00
alter vb dc=1.059413886e+00
option temp=100.911497
op
let idx = 3
wrdata C:/Users/udhav/DVD-Project/work/or_AND2_1.out idx i(Vdd) i(Va) i(Vb) v(g_nd) v(nand20_x) v(out)
destroy all
altermod nmos vth0=5.086013504e-01
altermod nmos toxe=9.078994006e-10
altermod nmos ndep=7.619890983e+18
altermod nmos u0=3.180702578e-02
altermod nmos xj=5.462563042e-09
altermod pmos vth0=-4.508813149e-01
altermod pmos toxe=9.574159685e-10
altermod pmos ndep=5.926166562e+18
altermod pmos u0=5.511276087e-03
altermod pmos xj=4.549619203e-09
alter vdd dc=9.935869906e-01
alter va dc=9.935869906e-01
alter vb dc=9.935869906e-01
option temp=-31.632908
op
let idx = 4
wrdata C:/Users/udhav/DVD-Project/work/or_AND2_1.out idx i(Vdd) i(Va) i(Vb) v(g_nd) v(nand20_x) v(out)
destroy all
.endc
.end
