* single pmos_off
.include C:/Users/udhav/DVD-Project/models/16nm_HP.pm
.options gmin=1e-18 abstol=1e-18 reltol=1e-6 vntol=1e-9
M1 d g s b pmos W=1.600000000e-08 L=1.600000000e-08
Vd d 0 0
Vg g 0 0
Vs s 0 0
Vb b 0 0
.control
set appendwrite
set wr_vecnames=0
altermod pmos vth0=-4.673340613e-01
altermod pmos toxe=1.009101490e-09
altermod pmos ndep=6.009178750e+18
altermod pmos u0=5.804104992e-03
altermod pmos xj=5.064115671e-09
alter m1 w=9.550020286e-08
alter vd dc=9.569933153e-01
alter vg dc=9.225231538e-01
alter vs dc=7.777221829e-01
alter vb dc=9.569933153e-01
option temp=79.327927
op
let idx = 0
wrdata C:/Users/udhav/DVD-Project/work/pmos_off_0.out idx i(Vd) i(Vg) i(Vs) i(Vb) @m1[id] @m1[igs] @m1[igd] @m1[igcs] @m1[igcd] @m1[igb] @m1[igidl] @m1[igisl] @m1[isub] @m1[ibd] @m1[ibs]
destroy all
altermod pmos vth0=-4.584699123e-01
altermod pmos toxe=9.850829415e-10
altermod pmos ndep=5.798437913e+18
altermod pmos u0=5.883433746e-03
altermod pmos xj=4.529172778e-09
alter m1 w=1.120813456e-07
alter vd dc=1.083086892e+00
alter vg dc=1.083442602e+00
alter vs dc=0.000000000e+00
alter vb dc=1.083442602e+00
option temp=20.386267
op
let idx = 1
wrdata C:/Users/udhav/DVD-Project/work/pmos_off_0.out idx i(Vd) i(Vg) i(Vs) i(Vb) @m1[id] @m1[igs] @m1[igd] @m1[igcs] @m1[igcd] @m1[igb] @m1[igidl] @m1[igisl] @m1[isub] @m1[ibd] @m1[ibs]
destroy all
altermod pmos vth0=-4.303819235e-01
altermod pmos toxe=1.012994078e-09
altermod pmos ndep=5.832494903e+18
altermod pmos u0=6.136929292e-03
altermod pmos xj=5.358880995e-09
alter m1 w=9.469015685e-08
alter vd dc=1.025226942e+00
alter vg dc=9.615948714e-01
alter vs dc=1.490784031e-01
alter vb dc=1.025226942e+00
option temp=108.308382
op
let idx = 2
wrdata C:/Users/udhav/DVD-Project/work/pmos_off_0.out idx i(Vd) i(Vg) i(Vs) i(Vb) @m1[id] @m1[igs] @m1[igd] @m1[igcs] @m1[igcd] @m1[igb] @m1[igidl] @m1[igisl] @m1[isub] @m1[ibd] @m1[ibs]
destroy all
altermod pmos vth0=-4.605416856e-01
altermod pmos toxe=1.010541691e-09
altermod pmos ndep=4.957130270e+18
altermod pmos u0=5.643754039e-03
altermod pmos xj=4.864304199e-09
alter m1 w=3.266356134e-08
alter vd dc=1.480806563e-03
alter vg dc=9.267139912e-01
alter vs dc=0.000000000e+00
alter vb dc=1.015632751e+00
option temp=117.803565
op
let idx = 3
wrdata C:/Users/udhav/DVD-Project/work/pmos_off_0.out idx i(Vd) i(Vg) i(Vs) i(Vb) @m1[id] @m1[igs] @m1[igd] @m1[igcs] @m1[igcd] @m1[igb] @m1[igidl] @m1[igisl] @m1[isub] @m1[ibd] @m1[ibs]
destroy all
altermod pmos vth0=-4.059791882e-01
altermod pmos toxe=1.039352723e-09
altermod pmos ndep=4.991965963e+18
altermod pmos u0=5.437486375e-03
altermod pmos xj=4.988623722e-09
alter m1 w=7.085845377e-08
alter vd dc=7.784492652e-01
alter vg dc=9.545623696e-01
alter vs dc=9.036243341e-01
alter vb dc=9.545623696e-01
option temp=-37.564909
op
let idx = 4
wrdata C:/Users/udhav/DVD-Project/work/pmos_off_0.out idx i(Vd) i(Vg) i(Vs) i(Vb) @m1[id] @m1[igs] @m1[igd] @m1[igcs] @m1[igcd] @m1[igb] @m1[igidl] @m1[igisl] @m1[isub] @m1[ibd] @m1[ibs]
destroy all
altermod pmos vth0=-4.597392393e-01
altermod pmos toxe=1.025657242e-09
altermod pmos ndep=6.018894854e+18
altermod pmos u0=5.498518046e-03
altermod pmos xj=5.006813378e-09
alter m1 w=3.176040247e-08
alter vd dc=0.000000000e+00
alter vg dc=1.087597695e+00
alter vs dc=2.556288320e-01
alter vb dc=1.087597695e+00
option temp=1.887720
op
let idx = 5
wrdata C:/Users/udhav/DVD-Project/work/pmos_off_0.out idx i(Vd) i(Vg) i(Vs) i(Vb) @m1[id] @m1[igs] @m1[igd] @m1[igcs] @m1[igcd] @m1[igb] @m1[igidl] @m1[igisl] @m1[isub] @m1[ibd] @m1[ibs]
destroy all
altermod pmos vth0=-4.313427718e-01
altermod pmos toxe=1.050564709e-09
altermod pmos ndep=5.093624099e+18
altermod pmos u0=6.372212618e-03
altermod pmos xj=5.015958095e-09
alter m1 w=1.031727149e-07
alter vd dc=9.740193715e-01
alter vg dc=8.878888690e-01
alter vs dc=2.858815965e-01
alter vb dc=9.740193715e-01
option temp=-31.197384
op
let idx = 6
wrdata C:/Users/udhav/DVD-Project/work/pmos_off_0.out idx i(Vd) i(Vg) i(Vs) i(Vb) @m1[id] @m1[igs] @m1[igd] @m1[igcs] @m1[igcd] @m1[igb] @m1[igidl] @m1[igisl] @m1[isub] @m1[ibd] @m1[ibs]
destroy all
altermod pmos vth0=-4.288436838e-01
altermod pmos toxe=1.011662726e-09
altermod pmos ndep=5.100568982e+18
altermod pmos u0=6.300479145e-03
altermod pmos xj=5.434496434e-09
alter m1 w=1.029607556e-07
alter vd dc=1.593426650e-02
alter vg dc=8.554079104e-01
alter vs dc=4.958120554e-02
alter vb dc=9.178744497e-01
option temp=111.160193
op
let idx = 7
wrdata C:/Users/udhav/DVD-Project/work/pmos_off_0.out idx i(Vd) i(Vg) i(Vs) i(Vb) @m1[id] @m1[igs] @m1[igd] @m1[igcs] @m1[igcd] @m1[igb] @m1[igidl] @m1[igisl] @m1[isub] @m1[ibd] @m1[ibs]
destroy all
altermod pmos vth0=-3.884199980e-01
altermod pmos toxe=9.345479021e-10
altermod pmos ndep=5.916549629e+18
altermod pmos u0=6.158896091e-03
altermod pmos xj=4.771646390e-09
alter m1 w=4.230040047e-08
alter vd dc=2.206079256e-01
alter vg dc=9.219529867e-01
alter vs dc=3.001585757e-01
alter vb dc=9.219529867e-01
option temp=118.868765
op
let idx = 8
wrdata C:/Users/udhav/DVD-Project/work/pmos_off_0.out idx i(Vd) i(Vg) i(Vs) i(Vb) @m1[id] @m1[igs] @m1[igd] @m1[igcs] @m1[igcd] @m1[igb] @m1[igidl] @m1[igisl] @m1[isub] @m1[ibd] @m1[ibs]
destroy all
altermod pmos vth0=-4.042361124e-01
altermod pmos toxe=9.975282217e-10
altermod pmos ndep=5.603755357e+18
altermod pmos u0=5.890629806e-03
altermod pmos xj=5.019198001e-09
alter m1 w=7.629838616e-08
alter vd dc=2.404475963e-01
alter vg dc=9.814416066e-01
alter vs dc=9.928041296e-01
alter vb dc=1.016307798e+00
option temp=-29.125483
op
let idx = 9
wrdata C:/Users/udhav/DVD-Project/work/pmos_off_0.out idx i(Vd) i(Vg) i(Vs) i(Vb) @m1[id] @m1[igs] @m1[igd] @m1[igcs] @m1[igcd] @m1[igb] @m1[igidl] @m1[igisl] @m1[isub] @m1[ibd] @m1[ibs]
destroy all
altermod pmos vth0=-3.896159398e-01
altermod pmos toxe=1.033126890e-09
altermod pmos ndep=5.687986183e+18
altermod pmos u0=5.463591238e-03
altermod pmos xj=4.596209399e-09
alter m1 w=3.618724350e-08
alter vd dc=7.237607568e-01
alter vg dc=9.375691952e-01
alter vs dc=0.000000000e+00
alter vb dc=1.024020248e+00
option temp=57.384215
op
let idx = 10
wrdata C:/Users/udhav/DVD-Project/work/pmos_off_0.out idx i(Vd) i(Vg) i(Vs) i(Vb) @m1[id] @m1[igs] @m1[igd] @m1[igcs] @m1[igcd] @m1[igb] @m1[igidl] @m1[igisl] @m1[isub] @m1[ibd] @m1[ibs]
destroy all
altermod pmos vth0=-4.304098792e-01
altermod pmos toxe=9.399586143e-10
altermod pmos ndep=5.767140492e+18
altermod pmos u0=5.874619989e-03
altermod pmos xj=4.986784140e-09
alter m1 w=1.239447464e-07
alter vd dc=9.446580153e-01
alter vg dc=8.820090357e-01
alter vs dc=0.000000000e+00
alter vb dc=9.497359565e-01
option temp=21.734062
op
let idx = 11
wrdata C:/Users/udhav/DVD-Project/work/pmos_off_0.out idx i(Vd) i(Vg) i(Vs) i(Vb) @m1[id] @m1[igs] @m1[igd] @m1[igcs] @m1[igcd] @m1[igb] @m1[igidl] @m1[igisl] @m1[isub] @m1[ibd] @m1[ibs]
destroy all
altermod pmos vth0=-4.339744034e-01
altermod pmos toxe=9.367300413e-10
altermod pmos ndep=5.960642241e+18
altermod pmos u0=6.583753498e-03
altermod pmos xj=4.707034789e-09
alter m1 w=2.216770815e-08
alter vd dc=9.561967087e-01
alter vg dc=9.561967087e-01
alter vs dc=4.310779749e-01
alter vb dc=9.561967087e-01
option temp=81.376461
op
let idx = 12
wrdata C:/Users/udhav/DVD-Project/work/pmos_off_0.out idx i(Vd) i(Vg) i(Vs) i(Vb) @m1[id] @m1[igs] @m1[igd] @m1[igcs] @m1[igcd] @m1[igb] @m1[igidl] @m1[igisl] @m1[isub] @m1[ibd] @m1[ibs]
destroy all
altermod pmos vth0=-3.898828072e-01
altermod pmos toxe=1.033908512e-09
altermod pmos ndep=5.453420355e+18
altermod pmos u0=6.366373404e-03
altermod pmos xj=5.112676338e-09
alter m1 w=3.681025218e-08
alter vd dc=7.662528566e-01
alter vg dc=9.050348660e-01
alter vs dc=9.050348660e-01
alter vb dc=9.050348660e-01
option temp=110.628760
op
let idx = 13
wrdata C:/Users/udhav/DVD-Project/work/pmos_off_0.out idx i(Vd) i(Vg) i(Vs) i(Vb) @m1[id] @m1[igs] @m1[igd] @m1[igcs] @m1[igcd] @m1[igb] @m1[igidl] @m1[igisl] @m1[isub] @m1[ibd] @m1[ibs]
destroy all
altermod pmos vth0=-4.174936077e-01
altermod pmos toxe=1.070672652e-09
altermod pmos ndep=6.002088209e+18
altermod pmos u0=5.448522717e-03
altermod pmos xj=5.258330838e-09
alter m1 w=1.022991010e-07
alter vd dc=0.000000000e+00
alter vg dc=9.131733495e-01
alter vs dc=8.814897063e-02
alter vb dc=9.131733495e-01
option temp=15.685617
op
let idx = 14
wrdata C:/Users/udhav/DVD-Project/work/pmos_off_0.out idx i(Vd) i(Vg) i(Vs) i(Vb) @m1[id] @m1[igs] @m1[igd] @m1[igcs] @m1[igcd] @m1[igb] @m1[igidl] @m1[igisl] @m1[isub] @m1[ibd] @m1[ibs]
destroy all
altermod pmos vth0=-4.095349462e-01
altermod pmos toxe=1.037194718e-09
altermod pmos ndep=5.816363509e+18
altermod pmos u0=5.473335352e-03
altermod pmos xj=5.040789021e-09
alter m1 w=1.613289211e-08
alter vd dc=1.088306662e+00
alter vg dc=1.088306662e+00
alter vs dc=1.088306662e+00
alter vb dc=1.088306662e+00
option temp=-2.421292
op
let idx = 15
wrdata C:/Users/udhav/DVD-Project/work/pmos_off_0.out idx i(Vd) i(Vg) i(Vs) i(Vb) @m1[id] @m1[igs] @m1[igd] @m1[igcs] @m1[igcd] @m1[igb] @m1[igidl] @m1[igisl] @m1[isub] @m1[ibd] @m1[ibs]
destroy all
altermod pmos vth0=-4.719772035e-01
altermod pmos toxe=1.080577160e-09
altermod pmos ndep=5.428145724e+18
altermod pmos u0=5.714045914e-03
altermod pmos xj=4.803692679e-09
alter m1 w=7.182788203e-08
alter vd dc=0.000000000e+00
alter vg dc=1.033812266e+00
alter vs dc=3.212161543e-01
alter vb dc=1.084803075e+00
option temp=53.716963
op
let idx = 16
wrdata C:/Users/udhav/DVD-Project/work/pmos_off_0.out idx i(Vd) i(Vg) i(Vs) i(Vb) @m1[id] @m1[igs] @m1[igd] @m1[igcs] @m1[igcd] @m1[igb] @m1[igidl] @m1[igisl] @m1[isub] @m1[ibd] @m1[ibs]
destroy all
altermod pmos vth0=-4.380885325e-01
altermod pmos toxe=1.098161437e-09
altermod pmos ndep=4.960423558e+18
altermod pmos u0=5.757612142e-03
altermod pmos xj=5.195266939e-09
alter m1 w=8.743841650e-08
alter vd dc=5.154955511e-01
alter vg dc=1.028082052e+00
alter vs dc=0.000000000e+00
alter vb dc=1.044516918e+00
option temp=32.304217
op
let idx = 17
wrdata C:/Users/udhav/DVD-Project/work/pmos_off_0.out idx i(Vd) i(Vg) i(Vs) i(Vb) @m1[id] @m1[igs] @m1[igd] @m1[igcs] @m1[igcd] @m1[igb] @m1[igidl] @m1[igisl] @m1[isub] @m1[ibd] @m1[ibs]
destroy all
altermod pmos vth0=-4.268170244e-01
altermod pmos toxe=9.082315110e-10
altermod pmos ndep=5.427805376e+18
altermod pmos u0=6.139825501e-03
altermod pmos xj=4.759355498e-09
alter m1 w=1.089566367e-07
alter vd dc=9.804995838e-01
alter vg dc=9.804995838e-01
alter vs dc=0.000000000e+00
alter vb dc=9.804995838e-01
option temp=79.697845
op
let idx = 18
wrdata C:/Users/udhav/DVD-Project/work/pmos_off_0.out idx i(Vd) i(Vg) i(Vs) i(Vb) @m1[id] @m1[igs] @m1[igd] @m1[igcs] @m1[igcd] @m1[igb] @m1[igidl] @m1[igisl] @m1[isub] @m1[ibd] @m1[ibs]
destroy all
altermod pmos vth0=-4.529269247e-01
altermod pmos toxe=9.118064313e-10
altermod pmos ndep=5.703907523e+18
altermod pmos u0=5.754367819e-03
altermod pmos xj=4.640925781e-09
alter m1 w=4.539132571e-08
alter vd dc=8.790731644e-01
alter vg dc=9.019921562e-01
alter vs dc=9.103688889e-01
alter vb dc=9.109993125e-01
option temp=-28.453403
op
let idx = 19
wrdata C:/Users/udhav/DVD-Project/work/pmos_off_0.out idx i(Vd) i(Vg) i(Vs) i(Vb) @m1[id] @m1[igs] @m1[igd] @m1[igcs] @m1[igcd] @m1[igb] @m1[igidl] @m1[igisl] @m1[isub] @m1[ibd] @m1[ibs]
destroy all
altermod pmos vth0=-4.030309005e-01
altermod pmos toxe=1.012083354e-09
altermod pmos ndep=5.637974799e+18
altermod pmos u0=5.463658055e-03
altermod pmos xj=5.395019952e-09
alter m1 w=2.406243793e-08
alter vd dc=3.975100928e-02
alter vg dc=1.037219206e+00
alter vs dc=7.179155153e-01
alter vb dc=1.037219206e+00
option temp=118.940445
op
let idx = 20
wrdata C:/Users/udhav/DVD-Project/work/pmos_off_0.out idx i(Vd) i(Vg) i(Vs) i(Vb) @m1[id] @m1[igs] @m1[igd] @m1[igcs] @m1[igcd] @m1[igb] @m1[igidl] @m1[igisl] @m1[isub] @m1[ibd] @m1[ibs]
destroy all
altermod pmos vth0=-4.741525969e-01
altermod pmos toxe=9.531381940e-10
altermod pmos ndep=5.364216754e+18
altermod pmos u0=6.091493263e-03
altermod pmos xj=4.881187598e-09
alter m1 w=5.696015545e-08
alter vd dc=3.671246617e-01
alter vg dc=9.574028618e-01
alter vs dc=8.757151530e-01
alter vb dc=9.824202915e-01
option temp=-21.159238
op
let idx = 21
wrdata C:/Users/udhav/DVD-Project/work/pmos_off_0.out idx i(Vd) i(Vg) i(Vs) i(Vb) @m1[id] @m1[igs] @m1[igd] @m1[igcs] @m1[igcd] @m1[igb] @m1[igidl] @m1[igisl] @m1[isub] @m1[ibd] @m1[ibs]
destroy all
altermod pmos vth0=-4.174640326e-01
altermod pmos toxe=9.435080549e-10
altermod pmos ndep=5.873199005e+18
altermod pmos u0=6.452128133e-03
altermod pmos xj=5.372995176e-09
alter m1 w=5.960987420e-08
alter vd dc=4.090931115e-05
alter vg dc=1.031535416e+00
alter vs dc=1.791723818e-01
alter vb dc=1.081930817e+00
option temp=96.788479
op
let idx = 22
wrdata C:/Users/udhav/DVD-Project/work/pmos_off_0.out idx i(Vd) i(Vg) i(Vs) i(Vb) @m1[id] @m1[igs] @m1[igd] @m1[igcs] @m1[igcd] @m1[igb] @m1[igidl] @m1[igisl] @m1[isub] @m1[ibd] @m1[ibs]
destroy all
altermod pmos vth0=-4.329601483e-01
altermod pmos toxe=1.009402413e-09
altermod pmos ndep=5.198086073e+18
altermod pmos u0=5.533590303e-03
altermod pmos xj=5.379159145e-09
alter m1 w=6.117381205e-08
alter vd dc=6.574335185e-01
alter vg dc=9.578094266e-01
alter vs dc=7.745267834e-01
alter vb dc=9.578094266e-01
option temp=-17.896328
op
let idx = 23
wrdata C:/Users/udhav/DVD-Project/work/pmos_off_0.out idx i(Vd) i(Vg) i(Vs) i(Vb) @m1[id] @m1[igs] @m1[igd] @m1[igcs] @m1[igcd] @m1[igb] @m1[igidl] @m1[igisl] @m1[isub] @m1[ibd] @m1[ibs]
destroy all
altermod pmos vth0=-4.506415591e-01
altermod pmos toxe=1.048694155e-09
altermod pmos ndep=5.755301017e+18
altermod pmos u0=6.226982840e-03
altermod pmos xj=5.243716263e-09
alter m1 w=1.249597155e-07
alter vd dc=1.027002553e+00
alter vg dc=1.046684009e+00
alter vs dc=4.193688553e-01
alter vb dc=1.046684009e+00
option temp=16.310031
op
let idx = 24
wrdata C:/Users/udhav/DVD-Project/work/pmos_off_0.out idx i(Vd) i(Vg) i(Vs) i(Vb) @m1[id] @m1[igs] @m1[igd] @m1[igcs] @m1[igcd] @m1[igb] @m1[igidl] @m1[igisl] @m1[isub] @m1[ibd] @m1[ibs]
destroy all
altermod pmos vth0=-4.036857635e-01
altermod pmos toxe=1.026190276e-09
altermod pmos ndep=5.600937426e+18
altermod pmos u0=6.530017169e-03
altermod pmos xj=5.172276111e-09
alter m1 w=8.811889274e-08
alter vd dc=1.306871637e-02
alter vg dc=1.088787627e+00
alter vs dc=1.084931948e+00
alter vb dc=1.088787627e+00
option temp=73.265622
op
let idx = 25
wrdata C:/Users/udhav/DVD-Project/work/pmos_off_0.out idx i(Vd) i(Vg) i(Vs) i(Vb) @m1[id] @m1[igs] @m1[igd] @m1[igcs] @m1[igcd] @m1[igb] @m1[igidl] @m1[igisl] @m1[isub] @m1[ibd] @m1[ibs]
destroy all
altermod pmos vth0=-4.260494856e-01
altermod pmos toxe=1.099668855e-09
altermod pmos ndep=5.775749428e+18
altermod pmos u0=6.194227765e-03
altermod pmos xj=5.294848794e-09
alter m1 w=4.440427740e-08
alter vd dc=9.879070061e-01
alter vg dc=1.009900180e+00
alter vs dc=0.000000000e+00
alter vb dc=1.009900180e+00
option temp=41.743475
op
let idx = 26
wrdata C:/Users/udhav/DVD-Project/work/pmos_off_0.out idx i(Vd) i(Vg) i(Vs) i(Vb) @m1[id] @m1[igs] @m1[igd] @m1[igcs] @m1[igcd] @m1[igb] @m1[igidl] @m1[igisl] @m1[isub] @m1[ibd] @m1[ibs]
destroy all
altermod pmos vth0=-4.591263607e-01
altermod pmos toxe=1.059180524e-09
altermod pmos ndep=5.094360333e+18
altermod pmos u0=5.450690210e-03
altermod pmos xj=5.366826372e-09
alter m1 w=2.564353849e-08
alter vd dc=2.561909725e-01
alter vg dc=1.028358845e+00
alter vs dc=6.178057841e-01
alter vb dc=1.033578479e+00
option temp=-10.864841
op
let idx = 27
wrdata C:/Users/udhav/DVD-Project/work/pmos_off_0.out idx i(Vd) i(Vg) i(Vs) i(Vb) @m1[id] @m1[igs] @m1[igd] @m1[igcs] @m1[igcd] @m1[igb] @m1[igidl] @m1[igisl] @m1[isub] @m1[ibd] @m1[ibs]
destroy all
altermod pmos vth0=-4.706113106e-01
altermod pmos toxe=9.538271867e-10
altermod pmos ndep=5.149715544e+18
altermod pmos u0=5.981035627e-03
altermod pmos xj=4.682021160e-09
alter m1 w=9.538163172e-08
alter vd dc=8.001116545e-01
alter vg dc=1.066884782e+00
alter vs dc=9.902352495e-01
alter vb dc=1.066884782e+00
option temp=45.370088
op
let idx = 28
wrdata C:/Users/udhav/DVD-Project/work/pmos_off_0.out idx i(Vd) i(Vg) i(Vs) i(Vb) @m1[id] @m1[igs] @m1[igd] @m1[igcs] @m1[igcd] @m1[igb] @m1[igidl] @m1[igisl] @m1[isub] @m1[ibd] @m1[ibs]
destroy all
altermod pmos vth0=-4.246044699e-01
altermod pmos toxe=9.469760613e-10
altermod pmos ndep=5.671579608e+18
altermod pmos u0=6.182746611e-03
altermod pmos xj=4.826205902e-09
alter m1 w=4.331363468e-08
alter vd dc=0.000000000e+00
alter vg dc=9.497649849e-01
alter vs dc=0.000000000e+00
alter vb dc=9.497649849e-01
option temp=39.188271
op
let idx = 29
wrdata C:/Users/udhav/DVD-Project/work/pmos_off_0.out idx i(Vd) i(Vg) i(Vs) i(Vb) @m1[id] @m1[igs] @m1[igd] @m1[igcs] @m1[igcd] @m1[igb] @m1[igidl] @m1[igisl] @m1[isub] @m1[ibd] @m1[ibs]
destroy all
altermod pmos vth0=-4.173137744e-01
altermod pmos toxe=1.031254915e-09
altermod pmos ndep=5.448184988e+18
altermod pmos u0=6.497675072e-03
altermod pmos xj=5.176509101e-09
alter m1 w=3.095714726e-08
alter vd dc=6.603371910e-02
alter vg dc=8.883258233e-01
alter vs dc=0.000000000e+00
alter vb dc=9.525330712e-01
option temp=-34.955675
op
let idx = 30
wrdata C:/Users/udhav/DVD-Project/work/pmos_off_0.out idx i(Vd) i(Vg) i(Vs) i(Vb) @m1[id] @m1[igs] @m1[igd] @m1[igcs] @m1[igcd] @m1[igb] @m1[igidl] @m1[igisl] @m1[isub] @m1[ibd] @m1[ibs]
destroy all
altermod pmos vth0=-3.994641771e-01
altermod pmos toxe=9.623533650e-10
altermod pmos ndep=5.928364599e+18
altermod pmos u0=6.294713942e-03
altermod pmos xj=5.228315813e-09
alter m1 w=8.446494718e-08
alter vd dc=9.998086220e-01
alter vg dc=9.998086220e-01
alter vs dc=2.828121489e-01
alter vb dc=9.998086220e-01
option temp=15.815842
op
let idx = 31
wrdata C:/Users/udhav/DVD-Project/work/pmos_off_0.out idx i(Vd) i(Vg) i(Vs) i(Vb) @m1[id] @m1[igs] @m1[igd] @m1[igcs] @m1[igcd] @m1[igb] @m1[igidl] @m1[igisl] @m1[isub] @m1[ibd] @m1[ibs]
destroy all
altermod pmos vth0=-4.563283770e-01
altermod pmos toxe=1.000157567e-09
altermod pmos ndep=5.092492635e+18
altermod pmos u0=5.778663064e-03
altermod pmos xj=4.644182784e-09
alter m1 w=4.486928717e-08
alter vd dc=0.000000000e+00
alter vg dc=9.416684582e-01
alter vs dc=3.291559158e-02
alter vb dc=1.030864658e+00
option temp=-10.903202
op
let idx = 32
wrdata C:/Users/udhav/DVD-Project/work/pmos_off_0.out idx i(Vd) i(Vg) i(Vs) i(Vb) @m1[id] @m1[igs] @m1[igd] @m1[igcs] @m1[igcd] @m1[igb] @m1[igidl] @m1[igisl] @m1[isub] @m1[ibd] @m1[ibs]
destroy all
altermod pmos vth0=-4.703753926e-01
altermod pmos toxe=1.054537008e-09
altermod pmos ndep=6.038284088e+18
altermod pmos u0=6.204509612e-03
altermod pmos xj=5.247830567e-09
alter m1 w=8.792890449e-08
alter vd dc=6.938652443e-03
alter vg dc=1.085574761e+00
alter vs dc=0.000000000e+00
alter vb dc=1.085574761e+00
option temp=-13.911335
op
let idx = 33
wrdata C:/Users/udhav/DVD-Project/work/pmos_off_0.out idx i(Vd) i(Vg) i(Vs) i(Vb) @m1[id] @m1[igs] @m1[igd] @m1[igcs] @m1[igcd] @m1[igb] @m1[igidl] @m1[igisl] @m1[isub] @m1[ibd] @m1[ibs]
destroy all
altermod pmos vth0=-3.896734073e-01
altermod pmos toxe=9.145584041e-10
altermod pmos ndep=5.633973307e+18
altermod pmos u0=6.571527169e-03
altermod pmos xj=4.860010574e-09
alter m1 w=9.010581659e-08
alter vd dc=0.000000000e+00
alter vg dc=9.064391815e-01
alter vs dc=9.064391815e-01
alter vb dc=9.064391815e-01
option temp=118.604030
op
let idx = 34
wrdata C:/Users/udhav/DVD-Project/work/pmos_off_0.out idx i(Vd) i(Vg) i(Vs) i(Vb) @m1[id] @m1[igs] @m1[igd] @m1[igcs] @m1[igcd] @m1[igb] @m1[igidl] @m1[igisl] @m1[isub] @m1[ibd] @m1[ibs]
destroy all
altermod pmos vth0=-3.930266085e-01
altermod pmos toxe=9.423040998e-10
altermod pmos ndep=5.099072860e+18
altermod pmos u0=6.546459008e-03
altermod pmos xj=4.545492370e-09
alter m1 w=1.066273665e-07
alter vd dc=7.051126404e-01
alter vg dc=9.970978748e-01
alter vs dc=1.259851358e-01
alter vb dc=9.970978748e-01
option temp=-1.526301
op
let idx = 35
wrdata C:/Users/udhav/DVD-Project/work/pmos_off_0.out idx i(Vd) i(Vg) i(Vs) i(Vb) @m1[id] @m1[igs] @m1[igd] @m1[igcs] @m1[igcd] @m1[igb] @m1[igidl] @m1[igisl] @m1[isub] @m1[ibd] @m1[ibs]
destroy all
altermod pmos vth0=-4.207926587e-01
altermod pmos toxe=9.994974939e-10
altermod pmos ndep=5.378255000e+18
altermod pmos u0=6.069334529e-03
altermod pmos xj=5.083531517e-09
alter m1 w=8.653969699e-08
alter vd dc=0.000000000e+00
alter vg dc=1.002650504e+00
alter vs dc=1.005351134e+00
alter vb dc=1.005351134e+00
option temp=-24.010522
op
let idx = 36
wrdata C:/Users/udhav/DVD-Project/work/pmos_off_0.out idx i(Vd) i(Vg) i(Vs) i(Vb) @m1[id] @m1[igs] @m1[igd] @m1[igcs] @m1[igcd] @m1[igb] @m1[igidl] @m1[igisl] @m1[isub] @m1[ibd] @m1[ibs]
destroy all
altermod pmos vth0=-4.326812949e-01
altermod pmos toxe=9.254051429e-10
altermod pmos ndep=5.068682200e+18
altermod pmos u0=5.889818445e-03
altermod pmos xj=4.504407166e-09
alter m1 w=5.067287879e-08
alter vd dc=3.899650410e-02
alter vg dc=9.915926592e-01
alter vs dc=9.993969179e-01
alter vb dc=1.077495329e+00
option temp=-2.705994
op
let idx = 37
wrdata C:/Users/udhav/DVD-Project/work/pmos_off_0.out idx i(Vd) i(Vg) i(Vs) i(Vb) @m1[id] @m1[igs] @m1[igd] @m1[igcs] @m1[igcd] @m1[igb] @m1[igidl] @m1[igisl] @m1[isub] @m1[ibd] @m1[ibs]
destroy all
altermod pmos vth0=-4.170746157e-01
altermod pmos toxe=1.006528267e-09
altermod pmos ndep=5.607912654e+18
altermod pmos u0=6.276330782e-03
altermod pmos xj=4.952282034e-09
alter m1 w=4.250161504e-08
alter vd dc=0.000000000e+00
alter vg dc=9.219688136e-01
alter vs dc=2.738786040e-02
alter vb dc=1.009877734e+00
option temp=-10.544276
op
let idx = 38
wrdata C:/Users/udhav/DVD-Project/work/pmos_off_0.out idx i(Vd) i(Vg) i(Vs) i(Vb) @m1[id] @m1[igs] @m1[igd] @m1[igcs] @m1[igcd] @m1[igb] @m1[igidl] @m1[igisl] @m1[isub] @m1[ibd] @m1[ibs]
destroy all
altermod pmos vth0=-4.535971432e-01
altermod pmos toxe=9.555760060e-10
altermod pmos ndep=5.403445563e+18
altermod pmos u0=6.184171738e-03
altermod pmos xj=4.654055082e-09
alter m1 w=2.414529766e-08
alter vd dc=9.431360393e-01
alter vg dc=9.280752436e-01
alter vs dc=2.065230949e-02
alter vb dc=9.431360393e-01
option temp=29.322365
op
let idx = 39
wrdata C:/Users/udhav/DVD-Project/work/pmos_off_0.out idx i(Vd) i(Vg) i(Vs) i(Vb) @m1[id] @m1[igs] @m1[igd] @m1[igcs] @m1[igcd] @m1[igb] @m1[igidl] @m1[igisl] @m1[isub] @m1[ibd] @m1[ibs]
destroy all
altermod pmos vth0=-4.135660171e-01
altermod pmos toxe=9.309221220e-10
altermod pmos ndep=5.657747282e+18
altermod pmos u0=5.885029819e-03
altermod pmos xj=4.826767515e-09
alter m1 w=1.002430999e-07
alter vd dc=7.004916968e-01
alter vg dc=9.246272574e-01
alter vs dc=0.000000000e+00
alter vb dc=9.246272574e-01
option temp=-27.135412
op
let idx = 40
wrdata C:/Users/udhav/DVD-Project/work/pmos_off_0.out idx i(Vd) i(Vg) i(Vs) i(Vb) @m1[id] @m1[igs] @m1[igd] @m1[igcs] @m1[igcd] @m1[igb] @m1[igidl] @m1[igisl] @m1[isub] @m1[ibd] @m1[ibs]
destroy all
altermod pmos vth0=-4.505736197e-01
altermod pmos toxe=1.012292346e-09
altermod pmos ndep=5.649049028e+18
altermod pmos u0=5.410118283e-03
altermod pmos xj=5.329125558e-09
alter m1 w=1.027182447e-07
alter vd dc=9.183819629e-01
alter vg dc=8.924758769e-01
alter vs dc=7.905911775e-01
alter vb dc=9.183819629e-01
option temp=87.016411
op
let idx = 41
wrdata C:/Users/udhav/DVD-Project/work/pmos_off_0.out idx i(Vd) i(Vg) i(Vs) i(Vb) @m1[id] @m1[igs] @m1[igd] @m1[igcs] @m1[igcd] @m1[igb] @m1[igidl] @m1[igisl] @m1[isub] @m1[ibd] @m1[ibs]
destroy all
altermod pmos vth0=-4.042290976e-01
altermod pmos toxe=1.079936443e-09
altermod pmos ndep=5.337310661e+18
altermod pmos u0=5.755594848e-03
altermod pmos xj=4.688549347e-09
alter m1 w=2.068085154e-08
alter vd dc=5.534788689e-02
alter vg dc=1.060580576e+00
alter vs dc=1.060580576e+00
alter vb dc=1.060580576e+00
option temp=38.188078
op
let idx = 42
wrdata C:/Users/udhav/DVD-Project/work/pmos_off_0.out idx i(Vd) i(Vg) i(Vs) i(Vb) @m1[id] @m1[igs] @m1[igd] @m1[igcs] @m1[igcd] @m1[igb] @m1[igidl] @m1[igisl] @m1[isub] @m1[ibd] @m1[ibs]
destroy all
altermod pmos vth0=-4.043120887e-01
altermod pmos toxe=9.862290492e-10
altermod pmos ndep=5.744067543e+18
altermod pmos u0=5.951067709e-03
altermod pmos xj=5.242904401e-09
alter m1 w=9.046339910e-08
alter vd dc=4.898394858e-01
alter vg dc=9.381112523e-01
alter vs dc=0.000000000e+00
alter vb dc=9.381112523e-01
option temp=22.277237
op
let idx = 43
wrdata C:/Users/udhav/DVD-Project/work/pmos_off_0.out idx i(Vd) i(Vg) i(Vs) i(Vb) @m1[id] @m1[igs] @m1[igd] @m1[igcs] @m1[igcd] @m1[igb] @m1[igidl] @m1[igisl] @m1[isub] @m1[ibd] @m1[ibs]
destroy all
altermod pmos vth0=-4.115539956e-01
altermod pmos toxe=1.043510774e-09
altermod pmos ndep=5.648024040e+18
altermod pmos u0=6.362846485e-03
altermod pmos xj=4.886423019e-09
alter m1 w=7.332949994e-08
alter vd dc=4.259739204e-01
alter vg dc=9.748902372e-01
alter vs dc=9.748902372e-01
alter vb dc=9.748902372e-01
option temp=26.855401
op
let idx = 44
wrdata C:/Users/udhav/DVD-Project/work/pmos_off_0.out idx i(Vd) i(Vg) i(Vs) i(Vb) @m1[id] @m1[igs] @m1[igd] @m1[igcs] @m1[igcd] @m1[igb] @m1[igidl] @m1[igisl] @m1[isub] @m1[ibd] @m1[ibs]
destroy all
altermod pmos vth0=-4.061449695e-01
altermod pmos toxe=9.877483399e-10
altermod pmos ndep=5.115913434e+18
altermod pmos u0=5.500058586e-03
altermod pmos xj=4.789613110e-09
alter m1 w=4.333897214e-08
alter vd dc=7.494820322e-02
alter vg dc=9.942001530e-01
alter vs dc=0.000000000e+00
alter vb dc=1.014572545e+00
option temp=78.044594
op
let idx = 45
wrdata C:/Users/udhav/DVD-Project/work/pmos_off_0.out idx i(Vd) i(Vg) i(Vs) i(Vb) @m1[id] @m1[igs] @m1[igd] @m1[igcs] @m1[igcd] @m1[igb] @m1[igidl] @m1[igisl] @m1[isub] @m1[ibd] @m1[ibs]
destroy all
altermod pmos vth0=-4.348917078e-01
altermod pmos toxe=9.518213005e-10
altermod pmos ndep=4.986724610e+18
altermod pmos u0=6.303243185e-03
altermod pmos xj=4.814369598e-09
alter m1 w=3.908917649e-08
alter vd dc=9.094780555e-01
alter vg dc=8.473310738e-01
alter vs dc=6.962542471e-03
alter vb dc=9.094780555e-01
option temp=85.329383
op
let idx = 46
wrdata C:/Users/udhav/DVD-Project/work/pmos_off_0.out idx i(Vd) i(Vg) i(Vs) i(Vb) @m1[id] @m1[igs] @m1[igd] @m1[igcs] @m1[igcd] @m1[igb] @m1[igidl] @m1[igisl] @m1[isub] @m1[ibd] @m1[ibs]
destroy all
altermod pmos vth0=-3.938271159e-01
altermod pmos toxe=1.089710094e-09
altermod pmos ndep=5.724475625e+18
altermod pmos u0=5.959941970e-03
altermod pmos xj=4.774392049e-09
alter m1 w=8.660263731e-08
alter vd dc=3.182709026e-01
alter vg dc=1.094250460e+00
alter vs dc=0.000000000e+00
alter vb dc=1.094250460e+00
option temp=-1.410700
op
let idx = 47
wrdata C:/Users/udhav/DVD-Project/work/pmos_off_0.out idx i(Vd) i(Vg) i(Vs) i(Vb) @m1[id] @m1[igs] @m1[igd] @m1[igcs] @m1[igcd] @m1[igb] @m1[igidl] @m1[igisl] @m1[isub] @m1[ibd] @m1[ibs]
destroy all
altermod pmos vth0=-4.275018101e-01
altermod pmos toxe=9.949128717e-10
altermod pmos ndep=5.556973655e+18
altermod pmos u0=6.437790772e-03
altermod pmos xj=4.779825350e-09
alter m1 w=8.635529500e-08
alter vd dc=1.088633486e+00
alter vg dc=1.093922109e+00
alter vs dc=1.051297719e+00
alter vb dc=1.093922109e+00
option temp=37.693484
op
let idx = 48
wrdata C:/Users/udhav/DVD-Project/work/pmos_off_0.out idx i(Vd) i(Vg) i(Vs) i(Vb) @m1[id] @m1[igs] @m1[igd] @m1[igcs] @m1[igcd] @m1[igb] @m1[igidl] @m1[igisl] @m1[isub] @m1[ibd] @m1[ibs]
destroy all
altermod pmos vth0=-4.563996878e-01
altermod pmos toxe=1.035600092e-09
altermod pmos ndep=5.895132736e+18
altermod pmos u0=6.142994945e-03
altermod pmos xj=4.634246394e-09
alter m1 w=3.922750530e-08
alter vd dc=2.338736188e-02
alter vg dc=8.756953275e-01
alter vs dc=0.000000000e+00
alter vb dc=9.599500927e-01
option temp=-12.118605
op
let idx = 49
wrdata C:/Users/udhav/DVD-Project/work/pmos_off_0.out idx i(Vd) i(Vg) i(Vs) i(Vb) @m1[id] @m1[igs] @m1[igd] @m1[igcs] @m1[igcd] @m1[igb] @m1[igidl] @m1[igisl] @m1[isub] @m1[ibd] @m1[ibs]
destroy all
altermod pmos vth0=-4.535336503e-01
altermod pmos toxe=9.532266721e-10
altermod pmos ndep=5.457748041e+18
altermod pmos u0=6.190635892e-03
altermod pmos xj=4.808998406e-09
alter m1 w=2.036894428e-08
alter vd dc=9.170575562e-01
alter vg dc=8.419004264e-01
alter vs dc=8.225536871e-01
alter vb dc=9.170575562e-01
option temp=40.592171
op
let idx = 50
wrdata C:/Users/udhav/DVD-Project/work/pmos_off_0.out idx i(Vd) i(Vg) i(Vs) i(Vb) @m1[id] @m1[igs] @m1[igd] @m1[igcs] @m1[igcd] @m1[igb] @m1[igidl] @m1[igisl] @m1[isub] @m1[ibd] @m1[ibs]
destroy all
altermod pmos vth0=-4.020527088e-01
altermod pmos toxe=1.077086007e-09
altermod pmos ndep=5.929876878e+18
altermod pmos u0=6.377521860e-03
altermod pmos xj=4.902924746e-09
alter m1 w=2.808724117e-08
alter vd dc=1.017200140e+00
alter vg dc=1.058598270e+00
alter vs dc=8.142292176e-01
alter vb dc=1.058598270e+00
option temp=-8.407665
op
let idx = 51
wrdata C:/Users/udhav/DVD-Project/work/pmos_off_0.out idx i(Vd) i(Vg) i(Vs) i(Vb) @m1[id] @m1[igs] @m1[igd] @m1[igcs] @m1[igcd] @m1[igb] @m1[igidl] @m1[igisl] @m1[isub] @m1[ibd] @m1[ibs]
destroy all
altermod pmos vth0=-4.434554287e-01
altermod pmos toxe=9.624669613e-10
altermod pmos ndep=5.753479648e+18
altermod pmos u0=6.278041218e-03
altermod pmos xj=5.204736319e-09
alter m1 w=1.214973393e-07
alter vd dc=5.922597676e-02
alter vg dc=9.269105147e-01
alter vs dc=1.678286243e-01
alter vb dc=9.269105147e-01
option temp=-3.836404
op
let idx = 52
wrdata C:/Users/udhav/DVD-Project/work/pmos_off_0.out idx i(Vd) i(Vg) i(Vs) i(Vb) @m1[id] @m1[igs] @m1[igd] @m1[igcs] @m1[igcd] @m1[igb] @m1[igidl] @m1[igisl] @m1[isub] @m1[ibd] @m1[ibs]
destroy all
altermod pmos vth0=-4.162666135e-01
altermod pmos toxe=9.446731857e-10
altermod pmos ndep=5.008784042e+18
altermod pmos u0=5.740796690e-03
altermod pmos xj=4.610686765e-09
alter m1 w=1.089654583e-07
alter vd dc=8.380298965e-01
alter vg dc=8.551477168e-01
alter vs dc=2.679730509e-01
alter vb dc=9.176541527e-01
option temp=-5.487174
op
let idx = 53
wrdata C:/Users/udhav/DVD-Project/work/pmos_off_0.out idx i(Vd) i(Vg) i(Vs) i(Vb) @m1[id] @m1[igs] @m1[igd] @m1[igcs] @m1[igcd] @m1[igb] @m1[igidl] @m1[igisl] @m1[isub] @m1[ibd] @m1[ibs]
destroy all
altermod pmos vth0=-4.702384600e-01
altermod pmos toxe=1.063586014e-09
altermod pmos ndep=5.792555678e+18
altermod pmos u0=6.548285857e-03
altermod pmos xj=4.562456262e-09
alter m1 w=1.170381143e-07
alter vd dc=2.311604381e-01
alter vg dc=8.731945198e-01
alter vs dc=1.566659263e-02
alter vb dc=9.511240403e-01
option temp=-11.309031
op
let idx = 54
wrdata C:/Users/udhav/DVD-Project/work/pmos_off_0.out idx i(Vd) i(Vg) i(Vs) i(Vb) @m1[id] @m1[igs] @m1[igd] @m1[igcs] @m1[igcd] @m1[igb] @m1[igidl] @m1[igisl] @m1[isub] @m1[ibd] @m1[ibs]
destroy all
altermod pmos vth0=-4.392947213e-01
altermod pmos toxe=1.011989087e-09
altermod pmos ndep=5.923014078e+18
altermod pmos u0=6.253180963e-03
altermod pmos xj=4.679601471e-09
alter m1 w=8.371828530e-08
alter vd dc=7.052166381e-01
alter vg dc=8.736215536e-01
alter vs dc=9.668293589e-01
alter vb dc=9.668293589e-01
option temp=109.954492
op
let idx = 55
wrdata C:/Users/udhav/DVD-Project/work/pmos_off_0.out idx i(Vd) i(Vg) i(Vs) i(Vb) @m1[id] @m1[igs] @m1[igd] @m1[igcs] @m1[igcd] @m1[igb] @m1[igidl] @m1[igisl] @m1[isub] @m1[ibd] @m1[ibs]
destroy all
altermod pmos vth0=-4.536458732e-01
altermod pmos toxe=1.070746046e-09
altermod pmos ndep=5.855900236e+18
altermod pmos u0=6.533794307e-03
altermod pmos xj=5.227527504e-09
alter m1 w=4.809457083e-08
alter vd dc=0.000000000e+00
alter vg dc=9.737305849e-01
alter vs dc=9.737305849e-01
alter vb dc=9.737305849e-01
option temp=-25.509550
op
let idx = 56
wrdata C:/Users/udhav/DVD-Project/work/pmos_off_0.out idx i(Vd) i(Vg) i(Vs) i(Vb) @m1[id] @m1[igs] @m1[igd] @m1[igcs] @m1[igcd] @m1[igb] @m1[igidl] @m1[igisl] @m1[isub] @m1[ibd] @m1[ibs]
destroy all
altermod pmos vth0=-4.242397259e-01
altermod pmos toxe=1.061127352e-09
altermod pmos ndep=5.784317878e+18
altermod pmos u0=6.295986245e-03
altermod pmos xj=5.145127449e-09
alter m1 w=5.964559638e-08
alter vd dc=1.108218499e-03
alter vg dc=9.936306216e-01
alter vs dc=9.936306216e-01
alter vb dc=9.936306216e-01
option temp=17.090800
op
let idx = 57
wrdata C:/Users/udhav/DVD-Project/work/pmos_off_0.out idx i(Vd) i(Vg) i(Vs) i(Vb) @m1[id] @m1[igs] @m1[igd] @m1[igcs] @m1[igcd] @m1[igb] @m1[igidl] @m1[igisl] @m1[isub] @m1[ibd] @m1[ibs]
destroy all
altermod pmos vth0=-4.339289975e-01
altermod pmos toxe=9.934931854e-10
altermod pmos ndep=5.491188417e+18
altermod pmos u0=6.235949916e-03
altermod pmos xj=5.224928444e-09
alter m1 w=4.779217819e-08
alter vd dc=1.148363304e-01
alter vg dc=8.986218434e-01
alter vs dc=4.662291733e-01
alter vb dc=9.544416621e-01
option temp=109.634825
op
let idx = 58
wrdata C:/Users/udhav/DVD-Project/work/pmos_off_0.out idx i(Vd) i(Vg) i(Vs) i(Vb) @m1[id] @m1[igs] @m1[igd] @m1[igcs] @m1[igcd] @m1[igb] @m1[igidl] @m1[igisl] @m1[isub] @m1[ibd] @m1[ibs]
destroy all
altermod pmos vth0=-3.912269883e-01
altermod pmos toxe=9.166260464e-10
altermod pmos ndep=5.653867018e+18
altermod pmos u0=6.330857516e-03
altermod pmos xj=5.277064984e-09
alter m1 w=7.298555803e-08
alter vd dc=0.000000000e+00
alter vg dc=9.381957535e-01
alter vs dc=5.241759587e-01
alter vb dc=9.392820645e-01
option temp=45.546309
op
let idx = 59
wrdata C:/Users/udhav/DVD-Project/work/pmos_off_0.out idx i(Vd) i(Vg) i(Vs) i(Vb) @m1[id] @m1[igs] @m1[igd] @m1[igcs] @m1[igcd] @m1[igb] @m1[igidl] @m1[igisl] @m1[isub] @m1[ibd] @m1[ibs]
destroy all
altermod pmos vth0=-4.042743498e-01
altermod pmos toxe=9.262460884e-10
altermod pmos ndep=5.962884739e+18
altermod pmos u0=5.471803052e-03
altermod pmos xj=4.798766386e-09
alter m1 w=4.296550953e-08
alter vd dc=4.835172196e-01
alter vg dc=9.841103083e-01
alter vs dc=2.236084840e-02
alter vb dc=1.038298898e+00
option temp=4.023656
op
let idx = 60
wrdata C:/Users/udhav/DVD-Project/work/pmos_off_0.out idx i(Vd) i(Vg) i(Vs) i(Vb) @m1[id] @m1[igs] @m1[igd] @m1[igcs] @m1[igcd] @m1[igb] @m1[igidl] @m1[igisl] @m1[isub] @m1[ibd] @m1[ibs]
destroy all
altermod pmos vth0=-3.963137911e-01
altermod pmos toxe=9.954012558e-10
altermod pmos ndep=5.319363827e+18
altermod pmos u0=6.398515803e-03
altermod pmos xj=5.286999855e-09
alter m1 w=8.175362120e-08
alter vd dc=9.021358894e-01
alter vg dc=9.021358894e-01
alter vs dc=3.367159342e-01
alter vb dc=9.021358894e-01
option temp=117.681054
op
let idx = 61
wrdata C:/Users/udhav/DVD-Project/work/pmos_off_0.out idx i(Vd) i(Vg) i(Vs) i(Vb) @m1[id] @m1[igs] @m1[igd] @m1[igcs] @m1[igcd] @m1[igb] @m1[igidl] @m1[igisl] @m1[isub] @m1[ibd] @m1[ibs]
destroy all
altermod pmos vth0=-4.490596440e-01
altermod pmos toxe=9.982886292e-10
altermod pmos ndep=5.539600650e+18
altermod pmos u0=5.441591763e-03
altermod pmos xj=5.165771173e-09
alter m1 w=3.842327536e-08
alter vd dc=9.532866302e-01
alter vg dc=9.532866302e-01
alter vs dc=1.030621358e-02
alter vb dc=9.532866302e-01
option temp=37.984712
op
let idx = 62
wrdata C:/Users/udhav/DVD-Project/work/pmos_off_0.out idx i(Vd) i(Vg) i(Vs) i(Vb) @m1[id] @m1[igs] @m1[igd] @m1[igcs] @m1[igcd] @m1[igb] @m1[igidl] @m1[igisl] @m1[isub] @m1[ibd] @m1[ibs]
destroy all
altermod pmos vth0=-4.260732414e-01
altermod pmos toxe=1.086226939e-09
altermod pmos ndep=5.909382566e+18
altermod pmos u0=6.072548292e-03
altermod pmos xj=5.389406528e-09
alter m1 w=7.119838245e-08
alter vd dc=1.184993789e-01
alter vg dc=9.190338461e-01
alter vs dc=1.898939459e-01
alter vb dc=9.350035172e-01
option temp=62.253681
op
let idx = 63
wrdata C:/Users/udhav/DVD-Project/work/pmos_off_0.out idx i(Vd) i(Vg) i(Vs) i(Vb) @m1[id] @m1[igs] @m1[igd] @m1[igcs] @m1[igcd] @m1[igb] @m1[igidl] @m1[igisl] @m1[isub] @m1[ibd] @m1[ibs]
destroy all
altermod pmos vth0=-4.375868387e-01
altermod pmos toxe=1.075665829e-09
altermod pmos ndep=5.280109483e+18
altermod pmos u0=5.963425862e-03
altermod pmos xj=4.884097985e-09
alter m1 w=1.274643419e-07
alter vd dc=3.193661330e-01
alter vg dc=1.061948585e+00
alter vs dc=1.045813360e+00
alter vb dc=1.061948585e+00
option temp=91.401060
op
let idx = 64
wrdata C:/Users/udhav/DVD-Project/work/pmos_off_0.out idx i(Vd) i(Vg) i(Vs) i(Vb) @m1[id] @m1[igs] @m1[igd] @m1[igcs] @m1[igcd] @m1[igb] @m1[igidl] @m1[igisl] @m1[isub] @m1[ibd] @m1[ibs]
destroy all
altermod pmos vth0=-4.005235462e-01
altermod pmos toxe=1.009622696e-09
altermod pmos ndep=5.731087963e+18
altermod pmos u0=6.114779825e-03
altermod pmos xj=5.314401128e-09
alter m1 w=1.609421320e-08
alter vd dc=9.998512278e-01
alter vg dc=9.288666285e-01
alter vs dc=1.324188069e-01
alter vb dc=1.003643658e+00
option temp=83.086609
op
let idx = 65
wrdata C:/Users/udhav/DVD-Project/work/pmos_off_0.out idx i(Vd) i(Vg) i(Vs) i(Vb) @m1[id] @m1[igs] @m1[igd] @m1[igcs] @m1[igcd] @m1[igb] @m1[igidl] @m1[igisl] @m1[isub] @m1[ibd] @m1[ibs]
destroy all
altermod pmos vth0=-4.704034816e-01
altermod pmos toxe=1.003444490e-09
altermod pmos ndep=5.340058403e+18
altermod pmos u0=6.096249332e-03
altermod pmos xj=4.532669043e-09
alter m1 w=3.758158805e-08
alter vd dc=5.835445032e-01
alter vg dc=9.938606873e-01
alter vs dc=8.143780007e-01
alter vb dc=9.938606873e-01
option temp=71.187078
op
let idx = 66
wrdata C:/Users/udhav/DVD-Project/work/pmos_off_0.out idx i(Vd) i(Vg) i(Vs) i(Vb) @m1[id] @m1[igs] @m1[igd] @m1[igcs] @m1[igcd] @m1[igb] @m1[igidl] @m1[igisl] @m1[isub] @m1[ibd] @m1[ibs]
destroy all
altermod pmos vth0=-3.997081281e-01
altermod pmos toxe=9.492751058e-10
altermod pmos ndep=4.958038793e+18
altermod pmos u0=6.427425249e-03
altermod pmos xj=5.081124054e-09
alter m1 w=3.842815169e-08
alter vd dc=1.043324059e-02
alter vg dc=9.974062152e-01
alter vs dc=9.337884253e-01
alter vb dc=1.075405375e+00
option temp=93.431825
op
let idx = 67
wrdata C:/Users/udhav/DVD-Project/work/pmos_off_0.out idx i(Vd) i(Vg) i(Vs) i(Vb) @m1[id] @m1[igs] @m1[igd] @m1[igcs] @m1[igcd] @m1[igb] @m1[igidl] @m1[igisl] @m1[isub] @m1[ibd] @m1[ibs]
destroy all
altermod pmos vth0=-4.651780349e-01
altermod pmos toxe=1.020656385e-09
altermod pmos ndep=5.962795205e+18
altermod pmos u0=5.781060303e-03
altermod pmos xj=5.407301603e-09
alter m1 w=8.209712406e-08
alter vd dc=2.320242412e-01
alter vg dc=9.413041231e-01
alter vs dc=3.846863486e-01
alter vb dc=9.413041231e-01
option temp=30.181424
op
let idx = 68
wrdata C:/Users/udhav/DVD-Project/work/pmos_off_0.out idx i(Vd) i(Vg) i(Vs) i(Vb) @m1[id] @m1[igs] @m1[igd] @m1[igcs] @m1[igcd] @m1[igb] @m1[igidl] @m1[igisl] @m1[isub] @m1[ibd] @m1[ibs]
destroy all
altermod pmos vth0=-4.054684033e-01
altermod pmos toxe=1.069548668e-09
altermod pmos ndep=5.484149302e+18
altermod pmos u0=6.451308538e-03
altermod pmos xj=5.197208678e-09
alter m1 w=6.784758594e-08
alter vd dc=1.011434013e+00
alter vg dc=9.129585885e-01
alter vs dc=4.190718272e-02
alter vb dc=1.011434013e+00
option temp=117.670131
op
let idx = 69
wrdata C:/Users/udhav/DVD-Project/work/pmos_off_0.out idx i(Vd) i(Vg) i(Vs) i(Vb) @m1[id] @m1[igs] @m1[igd] @m1[igcs] @m1[igcd] @m1[igb] @m1[igidl] @m1[igisl] @m1[isub] @m1[ibd] @m1[ibs]
destroy all
altermod pmos vth0=-4.354587561e-01
altermod pmos toxe=9.405956667e-10
altermod pmos ndep=5.572469179e+18
altermod pmos u0=6.266054856e-03
altermod pmos xj=5.193109525e-09
alter m1 w=7.610736003e-08
alter vd dc=1.198759052e-01
alter vg dc=1.017011977e+00
alter vs dc=0.000000000e+00
alter vb dc=1.089277590e+00
option temp=120.480530
op
let idx = 70
wrdata C:/Users/udhav/DVD-Project/work/pmos_off_0.out idx i(Vd) i(Vg) i(Vs) i(Vb) @m1[id] @m1[igs] @m1[igd] @m1[igcs] @m1[igcd] @m1[igb] @m1[igidl] @m1[igisl] @m1[isub] @m1[ibd] @m1[ibs]
destroy all
altermod pmos vth0=-4.167720810e-01
altermod pmos toxe=9.937955640e-10
altermod pmos ndep=5.110506752e+18
altermod pmos u0=6.553374181e-03
altermod pmos xj=4.891945895e-09
alter m1 w=1.145511397e-07
alter vd dc=3.633364776e-02
alter vg dc=8.950254565e-01
alter vs dc=4.786794739e-01
alter vb dc=9.202164755e-01
option temp=5.504872
op
let idx = 71
wrdata C:/Users/udhav/DVD-Project/work/pmos_off_0.out idx i(Vd) i(Vg) i(Vs) i(Vb) @m1[id] @m1[igs] @m1[igd] @m1[igcs] @m1[igcd] @m1[igb] @m1[igidl] @m1[igisl] @m1[isub] @m1[ibd] @m1[ibs]
destroy all
altermod pmos vth0=-4.308132450e-01
altermod pmos toxe=9.959737042e-10
altermod pmos ndep=5.764627157e+18
altermod pmos u0=5.688386115e-03
altermod pmos xj=4.608793316e-09
alter m1 w=1.029445429e-07
alter vd dc=1.037785679e+00
alter vg dc=1.037785679e+00
alter vs dc=1.079669137e-02
alter vb dc=1.037785679e+00
option temp=97.270227
op
let idx = 72
wrdata C:/Users/udhav/DVD-Project/work/pmos_off_0.out idx i(Vd) i(Vg) i(Vs) i(Vb) @m1[id] @m1[igs] @m1[igd] @m1[igcs] @m1[igcd] @m1[igb] @m1[igidl] @m1[igisl] @m1[isub] @m1[ibd] @m1[ibs]
destroy all
altermod pmos vth0=-4.694498462e-01
altermod pmos toxe=1.097170954e-09
altermod pmos ndep=5.023023813e+18
altermod pmos u0=6.216567714e-03
altermod pmos xj=4.531257662e-09
alter m1 w=1.783141088e-08
alter vd dc=0.000000000e+00
alter vg dc=9.905781979e-01
alter vs dc=4.965098461e-01
alter vb dc=1.020174937e+00
option temp=10.014690
op
let idx = 73
wrdata C:/Users/udhav/DVD-Project/work/pmos_off_0.out idx i(Vd) i(Vg) i(Vs) i(Vb) @m1[id] @m1[igs] @m1[igd] @m1[igcs] @m1[igcd] @m1[igb] @m1[igidl] @m1[igisl] @m1[isub] @m1[ibd] @m1[ibs]
destroy all
altermod pmos vth0=-4.356403014e-01
altermod pmos toxe=9.903813429e-10
altermod pmos ndep=5.736156805e+18
altermod pmos u0=6.160498809e-03
altermod pmos xj=5.294529307e-09
alter m1 w=1.108655251e-07
alter vd dc=3.969834382e-04
alter vg dc=1.070625654e+00
alter vs dc=8.127989041e-01
alter vb dc=1.070625654e+00
option temp=12.437657
op
let idx = 74
wrdata C:/Users/udhav/DVD-Project/work/pmos_off_0.out idx i(Vd) i(Vg) i(Vs) i(Vb) @m1[id] @m1[igs] @m1[igd] @m1[igcs] @m1[igcd] @m1[igb] @m1[igidl] @m1[igisl] @m1[isub] @m1[ibd] @m1[ibs]
destroy all
altermod pmos vth0=-4.697007723e-01
altermod pmos toxe=1.055809115e-09
altermod pmos ndep=5.423579842e+18
altermod pmos u0=5.703329261e-03
altermod pmos xj=5.346903879e-09
alter m1 w=3.375136259e-08
alter vd dc=8.113015264e-01
alter vg dc=1.054424443e+00
alter vs dc=5.282010856e-01
alter vb dc=1.054424443e+00
option temp=-30.341550
op
let idx = 75
wrdata C:/Users/udhav/DVD-Project/work/pmos_off_0.out idx i(Vd) i(Vg) i(Vs) i(Vb) @m1[id] @m1[igs] @m1[igd] @m1[igcs] @m1[igcd] @m1[igb] @m1[igidl] @m1[igisl] @m1[isub] @m1[ibd] @m1[ibs]
destroy all
altermod pmos vth0=-4.367325543e-01
altermod pmos toxe=1.064673886e-09
altermod pmos ndep=5.451924002e+18
altermod pmos u0=6.529188167e-03
altermod pmos xj=4.671642549e-09
alter m1 w=2.421552506e-08
alter vd dc=0.000000000e+00
alter vg dc=8.472166334e-01
alter vs dc=8.957860017e-01
alter vb dc=9.256707865e-01
option temp=94.013884
op
let idx = 76
wrdata C:/Users/udhav/DVD-Project/work/pmos_off_0.out idx i(Vd) i(Vg) i(Vs) i(Vb) @m1[id] @m1[igs] @m1[igd] @m1[igcs] @m1[igcd] @m1[igb] @m1[igidl] @m1[igisl] @m1[isub] @m1[ibd] @m1[ibs]
destroy all
altermod pmos vth0=-3.955155831e-01
altermod pmos toxe=1.011265955e-09
altermod pmos ndep=5.057531258e+18
altermod pmos u0=6.162304341e-03
altermod pmos xj=5.007099136e-09
alter m1 w=2.187472916e-08
alter vd dc=3.922196105e-01
alter vg dc=1.023055654e+00
alter vs dc=5.274592639e-03
alter vb dc=1.073331906e+00
option temp=-12.198751
op
let idx = 77
wrdata C:/Users/udhav/DVD-Project/work/pmos_off_0.out idx i(Vd) i(Vg) i(Vs) i(Vb) @m1[id] @m1[igs] @m1[igd] @m1[igcs] @m1[igcd] @m1[igb] @m1[igidl] @m1[igisl] @m1[isub] @m1[ibd] @m1[ibs]
destroy all
altermod pmos vth0=-4.633438462e-01
altermod pmos toxe=1.052196965e-09
altermod pmos ndep=5.571760594e+18
altermod pmos u0=6.018401084e-03
altermod pmos xj=4.633300784e-09
alter m1 w=6.665972543e-08
alter vd dc=7.696698600e-01
alter vg dc=9.592421184e-01
alter vs dc=8.241766954e-02
alter vb dc=9.592421184e-01
option temp=86.239577
op
let idx = 78
wrdata C:/Users/udhav/DVD-Project/work/pmos_off_0.out idx i(Vd) i(Vg) i(Vs) i(Vb) @m1[id] @m1[igs] @m1[igd] @m1[igcs] @m1[igcd] @m1[igb] @m1[igidl] @m1[igisl] @m1[isub] @m1[ibd] @m1[ibs]
destroy all
altermod pmos vth0=-4.005595522e-01
altermod pmos toxe=1.088691805e-09
altermod pmos ndep=5.737127453e+18
altermod pmos u0=6.192497643e-03
altermod pmos xj=4.561746180e-09
alter m1 w=1.244362591e-07
alter vd dc=9.767960490e-01
alter vg dc=1.005317714e+00
alter vs dc=8.877050239e-01
alter vb dc=1.041843211e+00
option temp=79.006649
op
let idx = 79
wrdata C:/Users/udhav/DVD-Project/work/pmos_off_0.out idx i(Vd) i(Vg) i(Vs) i(Vb) @m1[id] @m1[igs] @m1[igd] @m1[igcs] @m1[igcd] @m1[igb] @m1[igidl] @m1[igisl] @m1[isub] @m1[ibd] @m1[ibs]
destroy all
altermod pmos vth0=-4.626604922e-01
altermod pmos toxe=9.366690783e-10
altermod pmos ndep=5.016228321e+18
altermod pmos u0=6.350394988e-03
altermod pmos xj=4.773414331e-09
alter m1 w=1.254118974e-07
alter vd dc=9.968253979e-01
alter vg dc=9.793303862e-01
alter vs dc=0.000000000e+00
alter vb dc=1.074526444e+00
option temp=44.377962
op
let idx = 80
wrdata C:/Users/udhav/DVD-Project/work/pmos_off_0.out idx i(Vd) i(Vg) i(Vs) i(Vb) @m1[id] @m1[igs] @m1[igd] @m1[igcs] @m1[igcd] @m1[igb] @m1[igidl] @m1[igisl] @m1[isub] @m1[ibd] @m1[ibs]
destroy all
altermod pmos vth0=-4.624004537e-01
altermod pmos toxe=1.043950577e-09
altermod pmos ndep=5.318189673e+18
altermod pmos u0=5.610936146e-03
altermod pmos xj=4.998431002e-09
alter m1 w=1.145087246e-07
alter vd dc=1.070128765e+00
alter vg dc=1.032856629e+00
alter vs dc=3.577919279e-01
alter vb dc=1.070128765e+00
option temp=-2.093172
op
let idx = 81
wrdata C:/Users/udhav/DVD-Project/work/pmos_off_0.out idx i(Vd) i(Vg) i(Vs) i(Vb) @m1[id] @m1[igs] @m1[igd] @m1[igcs] @m1[igcd] @m1[igb] @m1[igidl] @m1[igisl] @m1[isub] @m1[ibd] @m1[ibs]
destroy all
altermod pmos vth0=-4.049499500e-01
altermod pmos toxe=9.847004082e-10
altermod pmos ndep=5.902159668e+18
altermod pmos u0=6.580231137e-03
altermod pmos xj=5.332705299e-09
alter m1 w=5.900964689e-08
alter vd dc=9.638939211e-01
alter vg dc=9.280766582e-01
alter vs dc=9.855173359e-01
alter vb dc=9.855173359e-01
option temp=90.286506
op
let idx = 82
wrdata C:/Users/udhav/DVD-Project/work/pmos_off_0.out idx i(Vd) i(Vg) i(Vs) i(Vb) @m1[id] @m1[igs] @m1[igd] @m1[igcs] @m1[igcd] @m1[igb] @m1[igidl] @m1[igisl] @m1[isub] @m1[ibd] @m1[ibs]
destroy all
altermod pmos vth0=-4.534372935e-01
altermod pmos toxe=1.059501472e-09
altermod pmos ndep=5.128995106e+18
altermod pmos u0=5.753167247e-03
altermod pmos xj=4.669032758e-09
alter m1 w=1.191987876e-07
alter vd dc=8.516385295e-01
alter vg dc=9.389212578e-01
alter vs dc=9.742824019e-01
alter vb dc=9.742824019e-01
option temp=-38.706409
op
let idx = 83
wrdata C:/Users/udhav/DVD-Project/work/pmos_off_0.out idx i(Vd) i(Vg) i(Vs) i(Vb) @m1[id] @m1[igs] @m1[igd] @m1[igcs] @m1[igcd] @m1[igb] @m1[igidl] @m1[igisl] @m1[isub] @m1[ibd] @m1[ibs]
destroy all
altermod pmos vth0=-4.276254672e-01
altermod pmos toxe=9.573239142e-10
altermod pmos ndep=5.463919348e+18
altermod pmos u0=5.628952002e-03
altermod pmos xj=4.789130194e-09
alter m1 w=1.062848980e-07
alter vd dc=5.840578545e-02
alter vg dc=8.716099663e-01
alter vs dc=9.012240265e-01
alter vb dc=9.039307593e-01
option temp=62.770958
op
let idx = 84
wrdata C:/Users/udhav/DVD-Project/work/pmos_off_0.out idx i(Vd) i(Vg) i(Vs) i(Vb) @m1[id] @m1[igs] @m1[igd] @m1[igcs] @m1[igcd] @m1[igb] @m1[igidl] @m1[igisl] @m1[isub] @m1[ibd] @m1[ibs]
destroy all
altermod pmos vth0=-4.255491121e-01
altermod pmos toxe=9.050915457e-10
altermod pmos ndep=5.680732430e+18
altermod pmos u0=5.492230706e-03
altermod pmos xj=5.227231297e-09
alter m1 w=1.134688402e-07
alter vd dc=4.641553496e-01
alter vg dc=9.111569979e-01
alter vs dc=9.570436259e-01
alter vb dc=9.590856221e-01
option temp=16.549740
op
let idx = 85
wrdata C:/Users/udhav/DVD-Project/work/pmos_off_0.out idx i(Vd) i(Vg) i(Vs) i(Vb) @m1[id] @m1[igs] @m1[igd] @m1[igcs] @m1[igcd] @m1[igb] @m1[igidl] @m1[igisl] @m1[isub] @m1[ibd] @m1[ibs]
destroy all
altermod pmos vth0=-4.214300152e-01
altermod pmos toxe=1.098460059e-09
altermod pmos ndep=6.005859507e+18
altermod pmos u0=6.425347757e-03
altermod pmos xj=4.844149471e-09
alter m1 w=1.121054082e-07
alter vd dc=9.426121023e-03
alter vg dc=9.771180545e-01
alter vs dc=1.070068566e-01
alter vb dc=9.771180545e-01
option temp=-0.882602
op
let idx = 86
wrdata C:/Users/udhav/DVD-Project/work/pmos_off_0.out idx i(Vd) i(Vg) i(Vs) i(Vb) @m1[id] @m1[igs] @m1[igd] @m1[igcs] @m1[igcd] @m1[igb] @m1[igidl] @m1[igisl] @m1[isub] @m1[ibd] @m1[ibs]
destroy all
altermod pmos vth0=-4.017956620e-01
altermod pmos toxe=1.013671146e-09
altermod pmos ndep=5.562094857e+18
altermod pmos u0=5.446083592e-03
altermod pmos xj=4.722286525e-09
alter m1 w=9.955876962e-08
alter vd dc=3.041596839e-01
alter vg dc=9.917812850e-01
alter vs dc=9.865332700e-01
alter vb dc=9.917812850e-01
option temp=-2.794963
op
let idx = 87
wrdata C:/Users/udhav/DVD-Project/work/pmos_off_0.out idx i(Vd) i(Vg) i(Vs) i(Vb) @m1[id] @m1[igs] @m1[igd] @m1[igcs] @m1[igcd] @m1[igb] @m1[igidl] @m1[igisl] @m1[isub] @m1[ibd] @m1[ibs]
destroy all
altermod pmos vth0=-4.530504430e-01
altermod pmos toxe=1.060814635e-09
altermod pmos ndep=5.459937233e+18
altermod pmos u0=5.403164607e-03
altermod pmos xj=4.784745566e-09
alter m1 w=1.098979823e-07
alter vd dc=9.109792059e-01
alter vg dc=9.294392874e-01
alter vs dc=8.527493002e-01
alter vb dc=9.296293628e-01
option temp=-34.179968
op
let idx = 88
wrdata C:/Users/udhav/DVD-Project/work/pmos_off_0.out idx i(Vd) i(Vg) i(Vs) i(Vb) @m1[id] @m1[igs] @m1[igd] @m1[igcs] @m1[igcd] @m1[igb] @m1[igidl] @m1[igisl] @m1[isub] @m1[ibd] @m1[ibs]
destroy all
altermod pmos vth0=-4.701007993e-01
altermod pmos toxe=9.762128746e-10
altermod pmos ndep=5.713668153e+18
altermod pmos u0=5.403835898e-03
altermod pmos xj=4.913597459e-09
alter m1 w=4.241757697e-08
alter vd dc=1.722861835e-01
alter vg dc=1.072825864e+00
alter vs dc=1.019761498e+00
alter vb dc=1.072825864e+00
option temp=31.297627
op
let idx = 89
wrdata C:/Users/udhav/DVD-Project/work/pmos_off_0.out idx i(Vd) i(Vg) i(Vs) i(Vb) @m1[id] @m1[igs] @m1[igd] @m1[igcs] @m1[igcd] @m1[igb] @m1[igidl] @m1[igisl] @m1[isub] @m1[ibd] @m1[ibs]
destroy all
altermod pmos vth0=-4.636101739e-01
altermod pmos toxe=9.434823791e-10
altermod pmos ndep=5.241949071e+18
altermod pmos u0=6.302907498e-03
altermod pmos xj=4.838974192e-09
alter m1 w=2.501315461e-08
alter vd dc=6.290989001e-01
alter vg dc=1.082542668e+00
alter vs dc=0.000000000e+00
alter vb dc=1.099778491e+00
option temp=-11.679105
op
let idx = 90
wrdata C:/Users/udhav/DVD-Project/work/pmos_off_0.out idx i(Vd) i(Vg) i(Vs) i(Vb) @m1[id] @m1[igs] @m1[igd] @m1[igcs] @m1[igcd] @m1[igb] @m1[igidl] @m1[igisl] @m1[isub] @m1[ibd] @m1[ibs]
destroy all
altermod pmos vth0=-4.089320651e-01
altermod pmos toxe=1.072202083e-09
altermod pmos ndep=5.726446951e+18
altermod pmos u0=5.628640754e-03
altermod pmos xj=4.828765923e-09
alter m1 w=1.138363694e-07
alter vd dc=5.825029332e-01
alter vg dc=1.056206873e+00
alter vs dc=4.374469259e-01
alter vb dc=1.056206873e+00
option temp=111.137762
op
let idx = 91
wrdata C:/Users/udhav/DVD-Project/work/pmos_off_0.out idx i(Vd) i(Vg) i(Vs) i(Vb) @m1[id] @m1[igs] @m1[igd] @m1[igcs] @m1[igcd] @m1[igb] @m1[igidl] @m1[igisl] @m1[isub] @m1[ibd] @m1[ibs]
destroy all
altermod pmos vth0=-4.114198824e-01
altermod pmos toxe=9.925336415e-10
altermod pmos ndep=5.067903932e+18
altermod pmos u0=5.935461383e-03
altermod pmos xj=5.229040670e-09
alter m1 w=1.227431624e-07
alter vd dc=4.330523328e-01
alter vg dc=1.099577462e+00
alter vs dc=7.193950799e-01
alter vb dc=1.099577462e+00
option temp=92.770519
op
let idx = 92
wrdata C:/Users/udhav/DVD-Project/work/pmos_off_0.out idx i(Vd) i(Vg) i(Vs) i(Vb) @m1[id] @m1[igs] @m1[igd] @m1[igcs] @m1[igcd] @m1[igb] @m1[igidl] @m1[igisl] @m1[isub] @m1[ibd] @m1[ibs]
destroy all
altermod pmos vth0=-4.264966857e-01
altermod pmos toxe=9.893837062e-10
altermod pmos ndep=5.059257295e+18
altermod pmos u0=6.076386935e-03
altermod pmos xj=5.074889388e-09
alter m1 w=8.772904206e-08
alter vd dc=3.692579054e-01
alter vg dc=9.202625564e-01
alter vs dc=9.189692795e-01
alter vb dc=9.202625564e-01
option temp=8.718151
op
let idx = 93
wrdata C:/Users/udhav/DVD-Project/work/pmos_off_0.out idx i(Vd) i(Vg) i(Vs) i(Vb) @m1[id] @m1[igs] @m1[igd] @m1[igcs] @m1[igcd] @m1[igb] @m1[igidl] @m1[igisl] @m1[isub] @m1[ibd] @m1[ibs]
destroy all
altermod pmos vth0=-4.534181690e-01
altermod pmos toxe=1.003115148e-09
altermod pmos ndep=5.404646944e+18
altermod pmos u0=6.247705055e-03
altermod pmos xj=4.673923043e-09
alter m1 w=1.218634051e-07
alter vd dc=2.464974717e-01
alter vg dc=8.958990148e-01
alter vs dc=5.902801353e-01
alter vb dc=9.150633100e-01
option temp=80.721715
op
let idx = 94
wrdata C:/Users/udhav/DVD-Project/work/pmos_off_0.out idx i(Vd) i(Vg) i(Vs) i(Vb) @m1[id] @m1[igs] @m1[igd] @m1[igcs] @m1[igcd] @m1[igb] @m1[igidl] @m1[igisl] @m1[isub] @m1[ibd] @m1[ibs]
destroy all
altermod pmos vth0=-4.720440159e-01
altermod pmos toxe=1.095504410e-09
altermod pmos ndep=5.181139868e+18
altermod pmos u0=5.427195672e-03
altermod pmos xj=5.099325464e-09
alter m1 w=5.868568017e-08
alter vd dc=4.160147745e-01
alter vg dc=9.630796216e-01
alter vs dc=5.177077973e-01
alter vb dc=9.630796216e-01
option temp=-2.900085
op
let idx = 95
wrdata C:/Users/udhav/DVD-Project/work/pmos_off_0.out idx i(Vd) i(Vg) i(Vs) i(Vb) @m1[id] @m1[igs] @m1[igd] @m1[igcs] @m1[igcd] @m1[igb] @m1[igidl] @m1[igisl] @m1[isub] @m1[ibd] @m1[ibs]
destroy all
altermod pmos vth0=-4.697068746e-01
altermod pmos toxe=1.007150960e-09
altermod pmos ndep=5.744304465e+18
altermod pmos u0=6.296966354e-03
altermod pmos xj=4.511508466e-09
alter m1 w=1.240081081e-07
alter vd dc=7.988153139e-01
alter vg dc=8.892527100e-01
alter vs dc=0.000000000e+00
alter vb dc=9.283352807e-01
option temp=-30.010005
op
let idx = 96
wrdata C:/Users/udhav/DVD-Project/work/pmos_off_0.out idx i(Vd) i(Vg) i(Vs) i(Vb) @m1[id] @m1[igs] @m1[igd] @m1[igcs] @m1[igcd] @m1[igb] @m1[igidl] @m1[igisl] @m1[isub] @m1[ibd] @m1[ibs]
destroy all
altermod pmos vth0=-4.343232107e-01
altermod pmos toxe=1.053923353e-09
altermod pmos ndep=5.319748732e+18
altermod pmos u0=5.552211827e-03
altermod pmos xj=4.839146284e-09
alter m1 w=6.765192086e-08
alter vd dc=5.403621881e-01
alter vg dc=9.809215333e-01
alter vs dc=9.809215333e-01
alter vb dc=9.809215333e-01
option temp=26.096886
op
let idx = 97
wrdata C:/Users/udhav/DVD-Project/work/pmos_off_0.out idx i(Vd) i(Vg) i(Vs) i(Vb) @m1[id] @m1[igs] @m1[igd] @m1[igcs] @m1[igcd] @m1[igb] @m1[igidl] @m1[igisl] @m1[isub] @m1[ibd] @m1[ibs]
destroy all
altermod pmos vth0=-4.668397976e-01
altermod pmos toxe=9.652433448e-10
altermod pmos ndep=5.545800376e+18
altermod pmos u0=6.546588659e-03
altermod pmos xj=5.177525124e-09
alter m1 w=3.341090792e-08
alter vd dc=0.000000000e+00
alter vg dc=1.051718522e+00
alter vs dc=0.000000000e+00
alter vb dc=1.051718522e+00
option temp=45.389227
op
let idx = 98
wrdata C:/Users/udhav/DVD-Project/work/pmos_off_0.out idx i(Vd) i(Vg) i(Vs) i(Vb) @m1[id] @m1[igs] @m1[igd] @m1[igcs] @m1[igcd] @m1[igb] @m1[igidl] @m1[igisl] @m1[isub] @m1[ibd] @m1[ibs]
destroy all
altermod pmos vth0=-4.399274385e-01
altermod pmos toxe=1.084400544e-09
altermod pmos ndep=6.030234228e+18
altermod pmos u0=6.378927196e-03
altermod pmos xj=4.983865936e-09
alter m1 w=2.674250011e-08
alter vd dc=3.453390925e-03
alter vg dc=9.261306760e-01
alter vs dc=4.919993730e-01
alter vb dc=9.403912145e-01
option temp=31.993946
op
let idx = 99
wrdata C:/Users/udhav/DVD-Project/work/pmos_off_0.out idx i(Vd) i(Vg) i(Vs) i(Vb) @m1[id] @m1[igs] @m1[igd] @m1[igcs] @m1[igcd] @m1[igb] @m1[igidl] @m1[igisl] @m1[isub] @m1[ibd] @m1[ibs]
destroy all
altermod pmos vth0=-4.127721442e-01
altermod pmos toxe=1.016370070e-09
altermod pmos ndep=5.695050777e+18
altermod pmos u0=5.496193261e-03
altermod pmos xj=5.196551362e-09
alter m1 w=1.275705757e-07
alter vd dc=0.000000000e+00
alter vg dc=9.301193905e-01
alter vs dc=9.104701803e-01
alter vb dc=9.301193905e-01
option temp=53.038770
op
let idx = 100
wrdata C:/Users/udhav/DVD-Project/work/pmos_off_0.out idx i(Vd) i(Vg) i(Vs) i(Vb) @m1[id] @m1[igs] @m1[igd] @m1[igcs] @m1[igcd] @m1[igb] @m1[igidl] @m1[igisl] @m1[isub] @m1[ibd] @m1[ibs]
destroy all
altermod pmos vth0=-4.282274179e-01
altermod pmos toxe=9.914558401e-10
altermod pmos ndep=6.024777210e+18
altermod pmos u0=6.318373006e-03
altermod pmos xj=5.052366438e-09
alter m1 w=8.757490177e-08
alter vd dc=1.648469817e-01
alter vg dc=9.077474411e-01
alter vs dc=9.539290708e-01
alter vb dc=9.539290708e-01
option temp=-30.003558
op
let idx = 101
wrdata C:/Users/udhav/DVD-Project/work/pmos_off_0.out idx i(Vd) i(Vg) i(Vs) i(Vb) @m1[id] @m1[igs] @m1[igd] @m1[igcs] @m1[igcd] @m1[igb] @m1[igidl] @m1[igisl] @m1[isub] @m1[ibd] @m1[ibs]
destroy all
altermod pmos vth0=-4.175271895e-01
altermod pmos toxe=1.082409872e-09
altermod pmos ndep=6.017535721e+18
altermod pmos u0=6.038581303e-03
altermod pmos xj=5.023723598e-09
alter m1 w=4.573182913e-08
alter vd dc=5.926685587e-01
alter vg dc=1.073213167e+00
alter vs dc=1.091189920e+00
alter vb dc=1.091189920e+00
option temp=-30.689292
op
let idx = 102
wrdata C:/Users/udhav/DVD-Project/work/pmos_off_0.out idx i(Vd) i(Vg) i(Vs) i(Vb) @m1[id] @m1[igs] @m1[igd] @m1[igcs] @m1[igcd] @m1[igb] @m1[igidl] @m1[igisl] @m1[isub] @m1[ibd] @m1[ibs]
destroy all
altermod pmos vth0=-4.414209580e-01
altermod pmos toxe=9.513010494e-10
altermod pmos ndep=5.480458471e+18
altermod pmos u0=6.556526998e-03
altermod pmos xj=5.005767509e-09
alter m1 w=9.859024921e-08
alter vd dc=1.247491619e-01
alter vg dc=8.397963217e-01
alter vs dc=9.005718637e-01
alter vb dc=9.005718637e-01
option temp=-14.452892
op
let idx = 103
wrdata C:/Users/udhav/DVD-Project/work/pmos_off_0.out idx i(Vd) i(Vg) i(Vs) i(Vb) @m1[id] @m1[igs] @m1[igd] @m1[igcs] @m1[igcd] @m1[igb] @m1[igidl] @m1[igisl] @m1[isub] @m1[ibd] @m1[ibs]
destroy all
altermod pmos vth0=-4.234547113e-01
altermod pmos toxe=9.397209240e-10
altermod pmos ndep=5.431923413e+18
altermod pmos u0=6.026738993e-03
altermod pmos xj=5.077354953e-09
alter m1 w=7.563207312e-08
alter vd dc=5.749647624e-01
alter vg dc=9.915051094e-01
alter vs dc=1.059656494e+00
alter vb dc=1.059656494e+00
option temp=12.542928
op
let idx = 104
wrdata C:/Users/udhav/DVD-Project/work/pmos_off_0.out idx i(Vd) i(Vg) i(Vs) i(Vb) @m1[id] @m1[igs] @m1[igd] @m1[igcs] @m1[igcd] @m1[igb] @m1[igidl] @m1[igisl] @m1[isub] @m1[ibd] @m1[ibs]
destroy all
altermod pmos vth0=-3.965056940e-01
altermod pmos toxe=1.066704788e-09
altermod pmos ndep=5.186021815e+18
altermod pmos u0=6.146581922e-03
altermod pmos xj=5.231038630e-09
alter m1 w=5.513164079e-08
alter vd dc=6.164618881e-01
alter vg dc=1.041877520e+00
alter vs dc=1.041877520e+00
alter vb dc=1.041877520e+00
option temp=41.920210
op
let idx = 105
wrdata C:/Users/udhav/DVD-Project/work/pmos_off_0.out idx i(Vd) i(Vg) i(Vs) i(Vb) @m1[id] @m1[igs] @m1[igd] @m1[igcs] @m1[igcd] @m1[igb] @m1[igidl] @m1[igisl] @m1[isub] @m1[ibd] @m1[ibs]
destroy all
altermod pmos vth0=-4.241521089e-01
altermod pmos toxe=9.918701462e-10
altermod pmos ndep=5.358052508e+18
altermod pmos u0=5.757857749e-03
altermod pmos xj=5.487672955e-09
alter m1 w=9.144362433e-08
alter vd dc=9.387625122e-01
alter vg dc=9.683402581e-01
alter vs dc=0.000000000e+00
alter vb dc=9.683402581e-01
option temp=50.150977
op
let idx = 106
wrdata C:/Users/udhav/DVD-Project/work/pmos_off_0.out idx i(Vd) i(Vg) i(Vs) i(Vb) @m1[id] @m1[igs] @m1[igd] @m1[igcs] @m1[igcd] @m1[igb] @m1[igidl] @m1[igisl] @m1[isub] @m1[ibd] @m1[ibs]
destroy all
altermod pmos vth0=-4.511757028e-01
altermod pmos toxe=1.038469927e-09
altermod pmos ndep=5.254910958e+18
altermod pmos u0=5.972492224e-03
altermod pmos xj=4.681825004e-09
alter m1 w=1.045889524e-07
alter vd dc=3.535992826e-02
alter vg dc=1.024980578e+00
alter vs dc=1.738853182e-02
alter vb dc=1.024980578e+00
option temp=22.561494
op
let idx = 107
wrdata C:/Users/udhav/DVD-Project/work/pmos_off_0.out idx i(Vd) i(Vg) i(Vs) i(Vb) @m1[id] @m1[igs] @m1[igd] @m1[igcs] @m1[igcd] @m1[igb] @m1[igidl] @m1[igisl] @m1[isub] @m1[ibd] @m1[ibs]
destroy all
altermod pmos vth0=-4.743231564e-01
altermod pmos toxe=9.267992223e-10
altermod pmos ndep=5.659408700e+18
altermod pmos u0=6.295466215e-03
altermod pmos xj=4.911500055e-09
alter m1 w=1.083546018e-07
alter vd dc=3.583182809e-01
alter vg dc=1.003790523e+00
alter vs dc=1.003790523e+00
alter vb dc=1.003790523e+00
option temp=64.523433
op
let idx = 108
wrdata C:/Users/udhav/DVD-Project/work/pmos_off_0.out idx i(Vd) i(Vg) i(Vs) i(Vb) @m1[id] @m1[igs] @m1[igd] @m1[igcs] @m1[igcd] @m1[igb] @m1[igidl] @m1[igisl] @m1[isub] @m1[ibd] @m1[ibs]
destroy all
altermod pmos vth0=-4.440190649e-01
altermod pmos toxe=9.257654551e-10
altermod pmos ndep=5.877503893e+18
altermod pmos u0=5.454460959e-03
altermod pmos xj=4.502087418e-09
alter m1 w=1.279097484e-07
alter vd dc=1.052378872e+00
alter vg dc=1.056721438e+00
alter vs dc=4.322557693e-02
alter vb dc=1.056721438e+00
option temp=15.056399
op
let idx = 109
wrdata C:/Users/udhav/DVD-Project/work/pmos_off_0.out idx i(Vd) i(Vg) i(Vs) i(Vb) @m1[id] @m1[igs] @m1[igd] @m1[igcs] @m1[igcd] @m1[igb] @m1[igidl] @m1[igisl] @m1[isub] @m1[ibd] @m1[ibs]
destroy all
altermod pmos vth0=-4.009965514e-01
altermod pmos toxe=1.081648505e-09
altermod pmos ndep=5.125929313e+18
altermod pmos u0=5.643254583e-03
altermod pmos xj=4.781925594e-09
alter m1 w=8.944618777e-08
alter vd dc=9.774244719e-01
alter vg dc=1.031909727e+00
alter vs dc=0.000000000e+00
alter vb dc=1.061140896e+00
option temp=16.834163
op
let idx = 110
wrdata C:/Users/udhav/DVD-Project/work/pmos_off_0.out idx i(Vd) i(Vg) i(Vs) i(Vb) @m1[id] @m1[igs] @m1[igd] @m1[igcs] @m1[igcd] @m1[igb] @m1[igidl] @m1[igisl] @m1[isub] @m1[ibd] @m1[ibs]
destroy all
altermod pmos vth0=-4.133710663e-01
altermod pmos toxe=1.098348739e-09
altermod pmos ndep=5.902874815e+18
altermod pmos u0=5.431971466e-03
altermod pmos xj=5.488412507e-09
alter m1 w=4.086037100e-08
alter vd dc=0.000000000e+00
alter vg dc=9.596695157e-01
alter vs dc=7.176004307e-01
alter vb dc=1.001306578e+00
option temp=42.606287
op
let idx = 111
wrdata C:/Users/udhav/DVD-Project/work/pmos_off_0.out idx i(Vd) i(Vg) i(Vs) i(Vb) @m1[id] @m1[igs] @m1[igd] @m1[igcs] @m1[igcd] @m1[igb] @m1[igidl] @m1[igisl] @m1[isub] @m1[ibd] @m1[ibs]
destroy all
altermod pmos vth0=-4.410235445e-01
altermod pmos toxe=1.036065364e-09
altermod pmos ndep=5.501958110e+18
altermod pmos u0=5.556931270e-03
altermod pmos xj=5.476697156e-09
alter m1 w=5.043947761e-08
alter vd dc=1.069106226e+00
alter vg dc=9.718908405e-01
alter vs dc=1.119468021e-02
alter vb dc=1.069106226e+00
option temp=13.355789
op
let idx = 112
wrdata C:/Users/udhav/DVD-Project/work/pmos_off_0.out idx i(Vd) i(Vg) i(Vs) i(Vb) @m1[id] @m1[igs] @m1[igd] @m1[igcs] @m1[igcd] @m1[igb] @m1[igidl] @m1[igisl] @m1[isub] @m1[ibd] @m1[ibs]
destroy all
altermod pmos vth0=-4.169051443e-01
altermod pmos toxe=1.029198991e-09
altermod pmos ndep=5.222279952e+18
altermod pmos u0=5.508549429e-03
altermod pmos xj=5.094769072e-09
alter m1 w=7.111731765e-08
alter vd dc=4.137582634e-02
alter vg dc=9.321536373e-01
alter vs dc=9.229592958e-02
alter vb dc=1.029786793e+00
option temp=58.163477
op
let idx = 113
wrdata C:/Users/udhav/DVD-Project/work/pmos_off_0.out idx i(Vd) i(Vg) i(Vs) i(Vb) @m1[id] @m1[igs] @m1[igd] @m1[igcs] @m1[igcd] @m1[igb] @m1[igidl] @m1[igisl] @m1[isub] @m1[ibd] @m1[ibs]
destroy all
altermod pmos vth0=-4.257864828e-01
altermod pmos toxe=1.045039182e-09
altermod pmos ndep=5.877119769e+18
altermod pmos u0=5.986083882e-03
altermod pmos xj=4.759762853e-09
alter m1 w=7.527435548e-08
alter vd dc=1.040921931e+00
alter vg dc=1.089696657e+00
alter vs dc=1.061362675e+00
alter vb dc=1.089696657e+00
option temp=24.734351
op
let idx = 114
wrdata C:/Users/udhav/DVD-Project/work/pmos_off_0.out idx i(Vd) i(Vg) i(Vs) i(Vb) @m1[id] @m1[igs] @m1[igd] @m1[igcs] @m1[igcd] @m1[igb] @m1[igidl] @m1[igisl] @m1[isub] @m1[ibd] @m1[ibs]
destroy all
altermod pmos vth0=-3.937278629e-01
altermod pmos toxe=1.087786596e-09
altermod pmos ndep=5.507653734e+18
altermod pmos u0=6.459664031e-03
altermod pmos xj=5.335832038e-09
alter m1 w=2.819699094e-08
alter vd dc=1.078970511e+00
alter vg dc=1.096616315e+00
alter vs dc=1.096616315e+00
alter vb dc=1.096616315e+00
option temp=63.943504
op
let idx = 115
wrdata C:/Users/udhav/DVD-Project/work/pmos_off_0.out idx i(Vd) i(Vg) i(Vs) i(Vb) @m1[id] @m1[igs] @m1[igd] @m1[igcs] @m1[igcd] @m1[igb] @m1[igidl] @m1[igisl] @m1[isub] @m1[ibd] @m1[ibs]
destroy all
altermod pmos vth0=-3.886973141e-01
altermod pmos toxe=1.083735029e-09
altermod pmos ndep=5.929733501e+18
altermod pmos u0=5.505737137e-03
altermod pmos xj=5.234925308e-09
alter m1 w=1.668103922e-08
alter vd dc=5.543210608e-01
alter vg dc=1.035984261e+00
alter vs dc=9.342719837e-03
alter vb dc=1.074093558e+00
option temp=-33.020407
op
let idx = 116
wrdata C:/Users/udhav/DVD-Project/work/pmos_off_0.out idx i(Vd) i(Vg) i(Vs) i(Vb) @m1[id] @m1[igs] @m1[igd] @m1[igcs] @m1[igcd] @m1[igb] @m1[igidl] @m1[igisl] @m1[isub] @m1[ibd] @m1[ibs]
destroy all
altermod pmos vth0=-4.397658749e-01
altermod pmos toxe=1.048523964e-09
altermod pmos ndep=5.118871109e+18
altermod pmos u0=5.884560875e-03
altermod pmos xj=4.540825663e-09
alter m1 w=8.202071055e-08
alter vd dc=9.421673076e-01
alter vg dc=9.440179364e-01
alter vs dc=9.465285179e-01
alter vb dc=9.617736863e-01
option temp=101.468234
op
let idx = 117
wrdata C:/Users/udhav/DVD-Project/work/pmos_off_0.out idx i(Vd) i(Vg) i(Vs) i(Vb) @m1[id] @m1[igs] @m1[igd] @m1[igcs] @m1[igcd] @m1[igb] @m1[igidl] @m1[igisl] @m1[isub] @m1[ibd] @m1[ibs]
destroy all
altermod pmos vth0=-4.378272660e-01
altermod pmos toxe=1.034697661e-09
altermod pmos ndep=5.768313402e+18
altermod pmos u0=5.713756968e-03
altermod pmos xj=5.163162322e-09
alter m1 w=1.085220043e-07
alter vd dc=1.935188077e-01
alter vg dc=9.721267859e-01
alter vs dc=0.000000000e+00
alter vb dc=9.721267859e-01
option temp=82.532157
op
let idx = 118
wrdata C:/Users/udhav/DVD-Project/work/pmos_off_0.out idx i(Vd) i(Vg) i(Vs) i(Vb) @m1[id] @m1[igs] @m1[igd] @m1[igcs] @m1[igcd] @m1[igb] @m1[igidl] @m1[igisl] @m1[isub] @m1[ibd] @m1[ibs]
destroy all
altermod pmos vth0=-4.091612358e-01
altermod pmos toxe=1.042086395e-09
altermod pmos ndep=5.101940762e+18
altermod pmos u0=5.764993191e-03
altermod pmos xj=5.104830714e-09
alter m1 w=1.277168183e-07
alter vd dc=1.012319930e+00
alter vg dc=1.039427306e+00
alter vs dc=4.118516369e-01
alter vb dc=1.088628575e+00
option temp=109.056848
op
let idx = 119
wrdata C:/Users/udhav/DVD-Project/work/pmos_off_0.out idx i(Vd) i(Vg) i(Vs) i(Vb) @m1[id] @m1[igs] @m1[igd] @m1[igcs] @m1[igcd] @m1[igb] @m1[igidl] @m1[igisl] @m1[isub] @m1[ibd] @m1[ibs]
destroy all
altermod pmos vth0=-4.436547194e-01
altermod pmos toxe=9.852350776e-10
altermod pmos ndep=5.905534608e+18
altermod pmos u0=6.157698092e-03
altermod pmos xj=5.364144027e-09
alter m1 w=9.299013880e-08
alter vd dc=0.000000000e+00
alter vg dc=1.035186761e+00
alter vs dc=1.035186761e+00
alter vb dc=1.035186761e+00
option temp=-28.770369
op
let idx = 120
wrdata C:/Users/udhav/DVD-Project/work/pmos_off_0.out idx i(Vd) i(Vg) i(Vs) i(Vb) @m1[id] @m1[igs] @m1[igd] @m1[igcs] @m1[igcd] @m1[igb] @m1[igidl] @m1[igisl] @m1[isub] @m1[ibd] @m1[ibs]
destroy all
altermod pmos vth0=-4.044285701e-01
altermod pmos toxe=9.977998434e-10
altermod pmos ndep=5.899392866e+18
altermod pmos u0=6.385146561e-03
altermod pmos xj=5.137637727e-09
alter m1 w=8.741999227e-08
alter vd dc=7.550346294e-01
alter vg dc=1.058412562e+00
alter vs dc=1.058412562e+00
alter vb dc=1.058412562e+00
option temp=-33.579180
op
let idx = 121
wrdata C:/Users/udhav/DVD-Project/work/pmos_off_0.out idx i(Vd) i(Vg) i(Vs) i(Vb) @m1[id] @m1[igs] @m1[igd] @m1[igcs] @m1[igcd] @m1[igb] @m1[igidl] @m1[igisl] @m1[isub] @m1[ibd] @m1[ibs]
destroy all
altermod pmos vth0=-4.450896277e-01
altermod pmos toxe=9.701893865e-10
altermod pmos ndep=5.086338210e+18
altermod pmos u0=5.668250383e-03
altermod pmos xj=5.244903885e-09
alter m1 w=6.287822884e-08
alter vd dc=9.865048464e-01
alter vg dc=9.206921463e-01
alter vs dc=9.865048464e-01
alter vb dc=9.865048464e-01
option temp=-22.138508
op
let idx = 122
wrdata C:/Users/udhav/DVD-Project/work/pmos_off_0.out idx i(Vd) i(Vg) i(Vs) i(Vb) @m1[id] @m1[igs] @m1[igd] @m1[igcs] @m1[igcd] @m1[igb] @m1[igidl] @m1[igisl] @m1[isub] @m1[ibd] @m1[ibs]
destroy all
altermod pmos vth0=-3.958822026e-01
altermod pmos toxe=1.082397865e-09
altermod pmos ndep=5.526975262e+18
altermod pmos u0=6.409537047e-03
altermod pmos xj=5.075453704e-09
alter m1 w=8.113593042e-08
alter vd dc=4.132527509e-01
alter vg dc=1.064039338e+00
alter vs dc=1.064039338e+00
alter vb dc=1.064039338e+00
option temp=104.205816
op
let idx = 123
wrdata C:/Users/udhav/DVD-Project/work/pmos_off_0.out idx i(Vd) i(Vg) i(Vs) i(Vb) @m1[id] @m1[igs] @m1[igd] @m1[igcs] @m1[igcd] @m1[igb] @m1[igidl] @m1[igisl] @m1[isub] @m1[ibd] @m1[ibs]
destroy all
altermod pmos vth0=-4.484809287e-01
altermod pmos toxe=1.031677879e-09
altermod pmos ndep=5.274212464e+18
altermod pmos u0=6.498397884e-03
altermod pmos xj=4.543372839e-09
alter m1 w=1.154185184e-07
alter vd dc=7.137120082e-01
alter vg dc=9.632859644e-01
alter vs dc=0.000000000e+00
alter vb dc=9.632859644e-01
option temp=102.689316
op
let idx = 124
wrdata C:/Users/udhav/DVD-Project/work/pmos_off_0.out idx i(Vd) i(Vg) i(Vs) i(Vb) @m1[id] @m1[igs] @m1[igd] @m1[igcs] @m1[igcd] @m1[igb] @m1[igidl] @m1[igisl] @m1[isub] @m1[ibd] @m1[ibs]
destroy all
altermod pmos vth0=-4.179673692e-01
altermod pmos toxe=1.023249068e-09
altermod pmos ndep=5.437458047e+18
altermod pmos u0=5.690531552e-03
altermod pmos xj=4.906057071e-09
alter m1 w=1.006297567e-07
alter vd dc=8.416947735e-01
alter vg dc=9.706415804e-01
alter vs dc=9.746410555e-01
alter vb dc=9.749062327e-01
option temp=87.221479
op
let idx = 125
wrdata C:/Users/udhav/DVD-Project/work/pmos_off_0.out idx i(Vd) i(Vg) i(Vs) i(Vb) @m1[id] @m1[igs] @m1[igd] @m1[igcs] @m1[igcd] @m1[igb] @m1[igidl] @m1[igisl] @m1[isub] @m1[ibd] @m1[ibs]
destroy all
altermod pmos vth0=-3.965280869e-01
altermod pmos toxe=9.288072176e-10
altermod pmos ndep=5.016469781e+18
altermod pmos u0=5.892690964e-03
altermod pmos xj=4.910025711e-09
alter m1 w=9.235916915e-08
alter vd dc=9.534459756e-01
alter vg dc=9.534459756e-01
alter vs dc=9.534459756e-01
alter vb dc=9.534459756e-01
option temp=72.971029
op
let idx = 126
wrdata C:/Users/udhav/DVD-Project/work/pmos_off_0.out idx i(Vd) i(Vg) i(Vs) i(Vb) @m1[id] @m1[igs] @m1[igd] @m1[igcs] @m1[igcd] @m1[igb] @m1[igidl] @m1[igisl] @m1[isub] @m1[ibd] @m1[ibs]
destroy all
altermod pmos vth0=-4.472545629e-01
altermod pmos toxe=9.181405772e-10
altermod pmos ndep=5.929778229e+18
altermod pmos u0=5.754600886e-03
altermod pmos xj=4.998799546e-09
alter m1 w=2.188624916e-08
alter vd dc=8.535395423e-01
alter vg dc=9.958281235e-01
alter vs dc=0.000000000e+00
alter vb dc=1.005483450e+00
option temp=-36.376597
op
let idx = 127
wrdata C:/Users/udhav/DVD-Project/work/pmos_off_0.out idx i(Vd) i(Vg) i(Vs) i(Vb) @m1[id] @m1[igs] @m1[igd] @m1[igcs] @m1[igcd] @m1[igb] @m1[igidl] @m1[igisl] @m1[isub] @m1[ibd] @m1[ibs]
destroy all
altermod pmos vth0=-4.397967908e-01
altermod pmos toxe=9.532946409e-10
altermod pmos ndep=5.760694892e+18
altermod pmos u0=6.167251540e-03
altermod pmos xj=5.442808381e-09
alter m1 w=6.512905660e-08
alter vd dc=4.161454002e-01
alter vg dc=8.496359539e-01
alter vs dc=6.182262587e-01
alter vb dc=9.326637245e-01
option temp=-25.566977
op
let idx = 128
wrdata C:/Users/udhav/DVD-Project/work/pmos_off_0.out idx i(Vd) i(Vg) i(Vs) i(Vb) @m1[id] @m1[igs] @m1[igd] @m1[igcs] @m1[igcd] @m1[igb] @m1[igidl] @m1[igisl] @m1[isub] @m1[ibd] @m1[ibs]
destroy all
altermod pmos vth0=-4.576229234e-01
altermod pmos toxe=1.043991955e-09
altermod pmos ndep=5.887564698e+18
altermod pmos u0=5.937896598e-03
altermod pmos xj=5.322649662e-09
alter m1 w=6.007233934e-08
alter vd dc=1.043914745e+00
alter vg dc=1.043914745e+00
alter vs dc=2.092460516e-02
alter vb dc=1.043914745e+00
option temp=79.105502
op
let idx = 129
wrdata C:/Users/udhav/DVD-Project/work/pmos_off_0.out idx i(Vd) i(Vg) i(Vs) i(Vb) @m1[id] @m1[igs] @m1[igd] @m1[igcs] @m1[igcd] @m1[igb] @m1[igidl] @m1[igisl] @m1[isub] @m1[ibd] @m1[ibs]
destroy all
altermod pmos vth0=-4.713065014e-01
altermod pmos toxe=9.734756758e-10
altermod pmos ndep=5.636051626e+18
altermod pmos u0=6.341637214e-03
altermod pmos xj=5.243822676e-09
alter m1 w=6.414876156e-08
alter vd dc=3.206820502e-03
alter vg dc=8.603431023e-01
alter vs dc=9.285069894e-01
alter vb dc=9.285069894e-01
option temp=-39.532852
op
let idx = 130
wrdata C:/Users/udhav/DVD-Project/work/pmos_off_0.out idx i(Vd) i(Vg) i(Vs) i(Vb) @m1[id] @m1[igs] @m1[igd] @m1[igcs] @m1[igcd] @m1[igb] @m1[igidl] @m1[igisl] @m1[isub] @m1[ibd] @m1[ibs]
destroy all
altermod pmos vth0=-3.937223020e-01
altermod pmos toxe=9.668884223e-10
altermod pmos ndep=5.783006082e+18
altermod pmos u0=6.453187351e-03
altermod pmos xj=4.695803674e-09
alter m1 w=1.106824220e-07
alter vd dc=3.182930074e-01
alter vg dc=1.070626799e+00
alter vs dc=1.070626799e+00
alter vb dc=1.070626799e+00
option temp=43.513263
op
let idx = 131
wrdata C:/Users/udhav/DVD-Project/work/pmos_off_0.out idx i(Vd) i(Vg) i(Vs) i(Vb) @m1[id] @m1[igs] @m1[igd] @m1[igcs] @m1[igcd] @m1[igb] @m1[igidl] @m1[igisl] @m1[isub] @m1[ibd] @m1[ibs]
destroy all
altermod pmos vth0=-4.285189244e-01
altermod pmos toxe=1.056245294e-09
altermod pmos ndep=5.282705698e+18
altermod pmos u0=5.772688103e-03
altermod pmos xj=4.983163001e-09
alter m1 w=9.059799789e-08
alter vd dc=8.834677801e-01
alter vg dc=9.076569103e-01
alter vs dc=0.000000000e+00
alter vb dc=9.077116567e-01
option temp=113.878893
op
let idx = 132
wrdata C:/Users/udhav/DVD-Project/work/pmos_off_0.out idx i(Vd) i(Vg) i(Vs) i(Vb) @m1[id] @m1[igs] @m1[igd] @m1[igcs] @m1[igcd] @m1[igb] @m1[igidl] @m1[igisl] @m1[isub] @m1[ibd] @m1[ibs]
destroy all
altermod pmos vth0=-4.012546449e-01
altermod pmos toxe=1.076927040e-09
altermod pmos ndep=5.140075382e+18
altermod pmos u0=5.785830947e-03
altermod pmos xj=4.713960427e-09
alter m1 w=1.224460927e-07
alter vd dc=8.314931883e-03
alter vg dc=9.562640246e-01
alter vs dc=2.801293724e-03
alter vb dc=9.562640246e-01
option temp=92.461633
op
let idx = 133
wrdata C:/Users/udhav/DVD-Project/work/pmos_off_0.out idx i(Vd) i(Vg) i(Vs) i(Vb) @m1[id] @m1[igs] @m1[igd] @m1[igcs] @m1[igcd] @m1[igb] @m1[igidl] @m1[igisl] @m1[isub] @m1[ibd] @m1[ibs]
destroy all
altermod pmos vth0=-4.714138815e-01
altermod pmos toxe=1.011993389e-09
altermod pmos ndep=5.607789219e+18
altermod pmos u0=5.414977998e-03
altermod pmos xj=5.108006924e-09
alter m1 w=3.322277024e-08
alter vd dc=1.834163764e-01
alter vg dc=1.035169922e+00
alter vs dc=2.726601991e-01
alter vb dc=1.035169922e+00
option temp=122.322450
op
let idx = 134
wrdata C:/Users/udhav/DVD-Project/work/pmos_off_0.out idx i(Vd) i(Vg) i(Vs) i(Vb) @m1[id] @m1[igs] @m1[igd] @m1[igcs] @m1[igcd] @m1[igb] @m1[igidl] @m1[igisl] @m1[isub] @m1[ibd] @m1[ibs]
destroy all
altermod pmos vth0=-4.686687960e-01
altermod pmos toxe=9.658675322e-10
altermod pmos ndep=5.142388402e+18
altermod pmos u0=5.711895751e-03
altermod pmos xj=4.867514415e-09
alter m1 w=5.256186911e-08
alter vd dc=0.000000000e+00
alter vg dc=9.794725591e-01
alter vs dc=0.000000000e+00
alter vb dc=9.794725591e-01
option temp=119.787352
op
let idx = 135
wrdata C:/Users/udhav/DVD-Project/work/pmos_off_0.out idx i(Vd) i(Vg) i(Vs) i(Vb) @m1[id] @m1[igs] @m1[igd] @m1[igcs] @m1[igcd] @m1[igb] @m1[igidl] @m1[igisl] @m1[isub] @m1[ibd] @m1[ibs]
destroy all
altermod pmos vth0=-4.057271534e-01
altermod pmos toxe=9.459664845e-10
altermod pmos ndep=5.755990568e+18
altermod pmos u0=6.046430363e-03
altermod pmos xj=5.084179682e-09
alter m1 w=2.696088889e-08
alter vd dc=6.421909115e-01
alter vg dc=1.000773649e+00
alter vs dc=9.429012486e-01
alter vb dc=1.000773649e+00
option temp=91.332720
op
let idx = 136
wrdata C:/Users/udhav/DVD-Project/work/pmos_off_0.out idx i(Vd) i(Vg) i(Vs) i(Vb) @m1[id] @m1[igs] @m1[igd] @m1[igcs] @m1[igcd] @m1[igb] @m1[igidl] @m1[igisl] @m1[isub] @m1[ibd] @m1[ibs]
destroy all
altermod pmos vth0=-4.233547536e-01
altermod pmos toxe=1.062667872e-09
altermod pmos ndep=5.925118127e+18
altermod pmos u0=6.055583785e-03
altermod pmos xj=5.493178956e-09
alter m1 w=1.228728609e-07
alter vd dc=5.828074657e-01
alter vg dc=1.025215822e+00
alter vs dc=9.662716199e-01
alter vb dc=1.069764078e+00
option temp=-24.378520
op
let idx = 137
wrdata C:/Users/udhav/DVD-Project/work/pmos_off_0.out idx i(Vd) i(Vg) i(Vs) i(Vb) @m1[id] @m1[igs] @m1[igd] @m1[igcs] @m1[igcd] @m1[igb] @m1[igidl] @m1[igisl] @m1[isub] @m1[ibd] @m1[ibs]
destroy all
altermod pmos vth0=-4.695819529e-01
altermod pmos toxe=9.043074957e-10
altermod pmos ndep=5.933878979e+18
altermod pmos u0=5.777201502e-03
altermod pmos xj=5.365716157e-09
alter m1 w=1.024987532e-07
alter vd dc=0.000000000e+00
alter vg dc=8.888059769e-01
alter vs dc=3.247404247e-01
alter vb dc=9.383244303e-01
option temp=32.587776
op
let idx = 138
wrdata C:/Users/udhav/DVD-Project/work/pmos_off_0.out idx i(Vd) i(Vg) i(Vs) i(Vb) @m1[id] @m1[igs] @m1[igd] @m1[igcs] @m1[igcd] @m1[igb] @m1[igidl] @m1[igisl] @m1[isub] @m1[ibd] @m1[ibs]
destroy all
altermod pmos vth0=-4.328353605e-01
altermod pmos toxe=1.056467976e-09
altermod pmos ndep=4.988574660e+18
altermod pmos u0=5.752875565e-03
altermod pmos xj=4.892765521e-09
alter m1 w=2.550802876e-08
alter vd dc=0.000000000e+00
alter vg dc=9.387835387e-01
alter vs dc=0.000000000e+00
alter vb dc=1.007779888e+00
option temp=-26.797774
op
let idx = 139
wrdata C:/Users/udhav/DVD-Project/work/pmos_off_0.out idx i(Vd) i(Vg) i(Vs) i(Vb) @m1[id] @m1[igs] @m1[igd] @m1[igcs] @m1[igcd] @m1[igb] @m1[igidl] @m1[igisl] @m1[isub] @m1[ibd] @m1[ibs]
destroy all
altermod pmos vth0=-4.033027860e-01
altermod pmos toxe=1.068928272e-09
altermod pmos ndep=5.231864202e+18
altermod pmos u0=5.754575492e-03
altermod pmos xj=5.136091327e-09
alter m1 w=7.333015079e-08
alter vd dc=9.035205870e-01
alter vg dc=9.286648661e-01
alter vs dc=0.000000000e+00
alter vb dc=9.437321845e-01
option temp=93.796381
op
let idx = 140
wrdata C:/Users/udhav/DVD-Project/work/pmos_off_0.out idx i(Vd) i(Vg) i(Vs) i(Vb) @m1[id] @m1[igs] @m1[igd] @m1[igcs] @m1[igcd] @m1[igb] @m1[igidl] @m1[igisl] @m1[isub] @m1[ibd] @m1[ibs]
destroy all
altermod pmos vth0=-4.371180662e-01
altermod pmos toxe=1.017073777e-09
altermod pmos ndep=5.560340811e+18
altermod pmos u0=5.896497613e-03
altermod pmos xj=5.400999515e-09
alter m1 w=8.323860264e-08
alter vd dc=7.898278412e-01
alter vg dc=9.039866350e-01
alter vs dc=7.137525174e-01
alter vb dc=9.216279620e-01
option temp=-39.190213
op
let idx = 141
wrdata C:/Users/udhav/DVD-Project/work/pmos_off_0.out idx i(Vd) i(Vg) i(Vs) i(Vb) @m1[id] @m1[igs] @m1[igd] @m1[igcs] @m1[igcd] @m1[igb] @m1[igidl] @m1[igisl] @m1[isub] @m1[ibd] @m1[ibs]
destroy all
altermod pmos vth0=-4.656398345e-01
altermod pmos toxe=1.068839624e-09
altermod pmos ndep=5.234761623e+18
altermod pmos u0=6.074153822e-03
altermod pmos xj=5.198271469e-09
alter m1 w=8.280236737e-08
alter vd dc=1.399824481e-01
alter vg dc=1.055849239e+00
alter vs dc=1.055849239e+00
alter vb dc=1.055849239e+00
option temp=45.600170
op
let idx = 142
wrdata C:/Users/udhav/DVD-Project/work/pmos_off_0.out idx i(Vd) i(Vg) i(Vs) i(Vb) @m1[id] @m1[igs] @m1[igd] @m1[igcs] @m1[igcd] @m1[igb] @m1[igidl] @m1[igisl] @m1[isub] @m1[ibd] @m1[ibs]
destroy all
altermod pmos vth0=-4.350114813e-01
altermod pmos toxe=9.727111794e-10
altermod pmos ndep=5.222305643e+18
altermod pmos u0=5.838995218e-03
altermod pmos xj=5.174041075e-09
alter m1 w=5.955614805e-08
alter vd dc=9.384487049e-01
alter vg dc=9.322500916e-01
alter vs dc=1.384941160e-01
alter vb dc=9.792530520e-01
option temp=69.951727
op
let idx = 143
wrdata C:/Users/udhav/DVD-Project/work/pmos_off_0.out idx i(Vd) i(Vg) i(Vs) i(Vb) @m1[id] @m1[igs] @m1[igd] @m1[igcs] @m1[igcd] @m1[igb] @m1[igidl] @m1[igisl] @m1[isub] @m1[ibd] @m1[ibs]
destroy all
altermod pmos vth0=-3.938230776e-01
altermod pmos toxe=1.094968401e-09
altermod pmos ndep=5.363911797e+18
altermod pmos u0=6.445988127e-03
altermod pmos xj=4.997306388e-09
alter m1 w=1.245061369e-07
alter vd dc=1.076557574e-01
alter vg dc=1.011424989e+00
alter vs dc=1.312811596e-03
alter vb dc=1.034108827e+00
option temp=108.713688
op
let idx = 144
wrdata C:/Users/udhav/DVD-Project/work/pmos_off_0.out idx i(Vd) i(Vg) i(Vs) i(Vb) @m1[id] @m1[igs] @m1[igd] @m1[igcs] @m1[igcd] @m1[igb] @m1[igidl] @m1[igisl] @m1[isub] @m1[ibd] @m1[ibs]
destroy all
altermod pmos vth0=-4.039087461e-01
altermod pmos toxe=9.548119802e-10
altermod pmos ndep=5.828516440e+18
altermod pmos u0=5.677823611e-03
altermod pmos xj=5.171799819e-09
alter m1 w=3.553271505e-08
alter vd dc=2.597173185e-02
alter vg dc=9.876707892e-01
alter vs dc=9.243068174e-01
alter vb dc=9.876707892e-01
option temp=107.023917
op
let idx = 145
wrdata C:/Users/udhav/DVD-Project/work/pmos_off_0.out idx i(Vd) i(Vg) i(Vs) i(Vb) @m1[id] @m1[igs] @m1[igd] @m1[igcs] @m1[igcd] @m1[igb] @m1[igidl] @m1[igisl] @m1[isub] @m1[ibd] @m1[ibs]
destroy all
altermod pmos vth0=-4.528387218e-01
altermod pmos toxe=1.052847003e-09
altermod pmos ndep=5.632820221e+18
altermod pmos u0=6.302079696e-03
altermod pmos xj=5.461409118e-09
alter m1 w=9.635271908e-08
alter vd dc=9.936730449e-01
alter vg dc=1.004544425e+00
alter vs dc=6.929864501e-01
alter vb dc=1.004544425e+00
option temp=46.690071
op
let idx = 146
wrdata C:/Users/udhav/DVD-Project/work/pmos_off_0.out idx i(Vd) i(Vg) i(Vs) i(Vb) @m1[id] @m1[igs] @m1[igd] @m1[igcs] @m1[igcd] @m1[igb] @m1[igidl] @m1[igisl] @m1[isub] @m1[ibd] @m1[ibs]
destroy all
altermod pmos vth0=-3.929100263e-01
altermod pmos toxe=9.544649246e-10
altermod pmos ndep=5.974350355e+18
altermod pmos u0=6.111925730e-03
altermod pmos xj=5.045132845e-09
alter m1 w=1.260988141e-07
alter vd dc=6.531960944e-01
alter vg dc=9.762276240e-01
alter vs dc=5.945279265e-01
alter vb dc=1.031010107e+00
option temp=71.179808
op
let idx = 147
wrdata C:/Users/udhav/DVD-Project/work/pmos_off_0.out idx i(Vd) i(Vg) i(Vs) i(Vb) @m1[id] @m1[igs] @m1[igd] @m1[igcs] @m1[igcd] @m1[igb] @m1[igidl] @m1[igisl] @m1[isub] @m1[ibd] @m1[ibs]
destroy all
altermod pmos vth0=-4.610590160e-01
altermod pmos toxe=9.336706941e-10
altermod pmos ndep=5.788430502e+18
altermod pmos u0=5.816797130e-03
altermod pmos xj=5.121825433e-09
alter m1 w=2.199726842e-08
alter vd dc=1.294925776e-01
alter vg dc=1.013820124e+00
alter vs dc=7.851797164e-01
alter vb dc=1.045870581e+00
option temp=52.720367
op
let idx = 148
wrdata C:/Users/udhav/DVD-Project/work/pmos_off_0.out idx i(Vd) i(Vg) i(Vs) i(Vb) @m1[id] @m1[igs] @m1[igd] @m1[igcs] @m1[igcd] @m1[igb] @m1[igidl] @m1[igisl] @m1[isub] @m1[ibd] @m1[ibs]
destroy all
altermod pmos vth0=-3.900276959e-01
altermod pmos toxe=9.451755960e-10
altermod pmos ndep=5.037594277e+18
altermod pmos u0=5.748462594e-03
altermod pmos xj=5.176770616e-09
alter m1 w=9.103089733e-08
alter vd dc=5.718345181e-01
alter vg dc=1.019494489e+00
alter vs dc=1.019494489e+00
alter vb dc=1.019494489e+00
option temp=8.245594
op
let idx = 149
wrdata C:/Users/udhav/DVD-Project/work/pmos_off_0.out idx i(Vd) i(Vg) i(Vs) i(Vb) @m1[id] @m1[igs] @m1[igd] @m1[igcs] @m1[igcd] @m1[igb] @m1[igidl] @m1[igisl] @m1[isub] @m1[ibd] @m1[ibs]
destroy all
altermod pmos vth0=-4.489440993e-01
altermod pmos toxe=1.080224674e-09
altermod pmos ndep=5.448511216e+18
altermod pmos u0=6.500969930e-03
altermod pmos xj=4.674749349e-09
alter m1 w=1.091229006e-07
alter vd dc=8.271114176e-01
alter vg dc=8.668645490e-01
alter vs dc=1.810481988e-01
alter vb dc=9.468596218e-01
option temp=66.459012
op
let idx = 150
wrdata C:/Users/udhav/DVD-Project/work/pmos_off_0.out idx i(Vd) i(Vg) i(Vs) i(Vb) @m1[id] @m1[igs] @m1[igd] @m1[igcs] @m1[igcd] @m1[igb] @m1[igidl] @m1[igisl] @m1[isub] @m1[ibd] @m1[ibs]
destroy all
altermod pmos vth0=-4.604613137e-01
altermod pmos toxe=9.098760234e-10
altermod pmos ndep=6.013964564e+18
altermod pmos u0=6.026271978e-03
altermod pmos xj=4.777563259e-09
alter m1 w=7.406832223e-08
alter vd dc=6.749068826e-01
alter vg dc=1.016467102e+00
alter vs dc=8.174222858e-01
alter vb dc=1.016467102e+00
option temp=15.639236
op
let idx = 151
wrdata C:/Users/udhav/DVD-Project/work/pmos_off_0.out idx i(Vd) i(Vg) i(Vs) i(Vb) @m1[id] @m1[igs] @m1[igd] @m1[igcs] @m1[igcd] @m1[igb] @m1[igidl] @m1[igisl] @m1[isub] @m1[ibd] @m1[ibs]
destroy all
altermod pmos vth0=-4.515794818e-01
altermod pmos toxe=9.548850873e-10
altermod pmos ndep=5.033894294e+18
altermod pmos u0=6.524756397e-03
altermod pmos xj=5.344760370e-09
alter m1 w=1.822829095e-08
alter vd dc=0.000000000e+00
alter vg dc=1.027324634e+00
alter vs dc=1.055897773e+00
alter vb dc=1.055897773e+00
option temp=71.152039
op
let idx = 152
wrdata C:/Users/udhav/DVD-Project/work/pmos_off_0.out idx i(Vd) i(Vg) i(Vs) i(Vb) @m1[id] @m1[igs] @m1[igd] @m1[igcs] @m1[igcd] @m1[igb] @m1[igidl] @m1[igisl] @m1[isub] @m1[ibd] @m1[ibs]
destroy all
altermod pmos vth0=-4.071166534e-01
altermod pmos toxe=1.053853489e-09
altermod pmos ndep=5.821905268e+18
altermod pmos u0=5.980277165e-03
altermod pmos xj=4.878644416e-09
alter m1 w=7.337324498e-08
alter vd dc=7.786527978e-01
alter vg dc=9.974302759e-01
alter vs dc=9.974302759e-01
alter vb dc=9.974302759e-01
option temp=102.688189
op
let idx = 153
wrdata C:/Users/udhav/DVD-Project/work/pmos_off_0.out idx i(Vd) i(Vg) i(Vs) i(Vb) @m1[id] @m1[igs] @m1[igd] @m1[igcs] @m1[igcd] @m1[igb] @m1[igidl] @m1[igisl] @m1[isub] @m1[ibd] @m1[ibs]
destroy all
altermod pmos vth0=-4.284875108e-01
altermod pmos toxe=1.076204537e-09
altermod pmos ndep=5.815122808e+18
altermod pmos u0=6.215302064e-03
altermod pmos xj=4.739786458e-09
alter m1 w=3.084665463e-08
alter vd dc=1.045546680e+00
alter vg dc=1.013386608e+00
alter vs dc=2.712921119e-01
alter vb dc=1.057482325e+00
option temp=-34.790271
op
let idx = 154
wrdata C:/Users/udhav/DVD-Project/work/pmos_off_0.out idx i(Vd) i(Vg) i(Vs) i(Vb) @m1[id] @m1[igs] @m1[igd] @m1[igcs] @m1[igcd] @m1[igb] @m1[igidl] @m1[igisl] @m1[isub] @m1[ibd] @m1[ibs]
destroy all
altermod pmos vth0=-4.025339542e-01
altermod pmos toxe=1.049136623e-09
altermod pmos ndep=5.041315569e+18
altermod pmos u0=6.455867316e-03
altermod pmos xj=4.843708083e-09
alter m1 w=1.243465195e-07
alter vd dc=2.147152958e-01
alter vg dc=1.059450029e+00
alter vs dc=3.095600505e-03
alter vb dc=1.097897066e+00
option temp=-17.549076
op
let idx = 155
wrdata C:/Users/udhav/DVD-Project/work/pmos_off_0.out idx i(Vd) i(Vg) i(Vs) i(Vb) @m1[id] @m1[igs] @m1[igd] @m1[igcs] @m1[igcd] @m1[igb] @m1[igidl] @m1[igisl] @m1[isub] @m1[ibd] @m1[ibs]
destroy all
altermod pmos vth0=-4.393958577e-01
altermod pmos toxe=1.081414128e-09
altermod pmos ndep=5.350460621e+18
altermod pmos u0=6.112372670e-03
altermod pmos xj=4.746698908e-09
alter m1 w=2.439885732e-08
alter vd dc=3.135317581e-01
alter vg dc=9.853936861e-01
alter vs dc=9.853936861e-01
alter vb dc=9.853936861e-01
option temp=65.172108
op
let idx = 156
wrdata C:/Users/udhav/DVD-Project/work/pmos_off_0.out idx i(Vd) i(Vg) i(Vs) i(Vb) @m1[id] @m1[igs] @m1[igd] @m1[igcs] @m1[igcd] @m1[igb] @m1[igidl] @m1[igisl] @m1[isub] @m1[ibd] @m1[ibs]
destroy all
altermod pmos vth0=-4.496280295e-01
altermod pmos toxe=1.049531842e-09
altermod pmos ndep=5.807408113e+18
altermod pmos u0=5.556620271e-03
altermod pmos xj=4.574390170e-09
alter m1 w=3.289666435e-08
alter vd dc=9.849231419e-02
alter vg dc=8.700745345e-01
alter vs dc=9.502293460e-01
alter vb dc=9.502293460e-01
option temp=-38.554831
op
let idx = 157
wrdata C:/Users/udhav/DVD-Project/work/pmos_off_0.out idx i(Vd) i(Vg) i(Vs) i(Vb) @m1[id] @m1[igs] @m1[igd] @m1[igcs] @m1[igcd] @m1[igb] @m1[igidl] @m1[igisl] @m1[isub] @m1[ibd] @m1[ibs]
destroy all
altermod pmos vth0=-4.643032633e-01
altermod pmos toxe=9.673514162e-10
altermod pmos ndep=5.222255870e+18
altermod pmos u0=6.341017089e-03
altermod pmos xj=4.895313147e-09
alter m1 w=5.324475662e-08
alter vd dc=2.332388051e-01
alter vg dc=9.899770662e-01
alter vs dc=5.438663822e-01
alter vb dc=9.899770662e-01
option temp=99.308187
op
let idx = 158
wrdata C:/Users/udhav/DVD-Project/work/pmos_off_0.out idx i(Vd) i(Vg) i(Vs) i(Vb) @m1[id] @m1[igs] @m1[igd] @m1[igcs] @m1[igcd] @m1[igb] @m1[igidl] @m1[igisl] @m1[isub] @m1[ibd] @m1[ibs]
destroy all
altermod pmos vth0=-3.939530579e-01
altermod pmos toxe=1.026247078e-09
altermod pmos ndep=5.477930393e+18
altermod pmos u0=5.655592644e-03
altermod pmos xj=4.579602613e-09
alter m1 w=3.554817785e-08
alter vd dc=1.053629904e+00
alter vg dc=1.053629904e+00
alter vs dc=5.444051510e-01
alter vb dc=1.053629904e+00
option temp=117.408689
op
let idx = 159
wrdata C:/Users/udhav/DVD-Project/work/pmos_off_0.out idx i(Vd) i(Vg) i(Vs) i(Vb) @m1[id] @m1[igs] @m1[igd] @m1[igcs] @m1[igcd] @m1[igb] @m1[igidl] @m1[igisl] @m1[isub] @m1[ibd] @m1[ibs]
destroy all
altermod pmos vth0=-4.576528484e-01
altermod pmos toxe=1.076746716e-09
altermod pmos ndep=5.104803549e+18
altermod pmos u0=5.756224182e-03
altermod pmos xj=5.166164986e-09
alter m1 w=6.190580423e-08
alter vd dc=4.422665467e-01
alter vg dc=9.745681697e-01
alter vs dc=9.710639345e-01
alter vb dc=9.745681697e-01
option temp=28.273700
op
let idx = 160
wrdata C:/Users/udhav/DVD-Project/work/pmos_off_0.out idx i(Vd) i(Vg) i(Vs) i(Vb) @m1[id] @m1[igs] @m1[igd] @m1[igcs] @m1[igcd] @m1[igb] @m1[igidl] @m1[igisl] @m1[isub] @m1[ibd] @m1[ibs]
destroy all
altermod pmos vth0=-4.444557964e-01
altermod pmos toxe=1.077682513e-09
altermod pmos ndep=5.144748748e+18
altermod pmos u0=5.483770910e-03
altermod pmos xj=5.439550875e-09
alter m1 w=2.565520725e-08
alter vd dc=5.673684045e-02
alter vg dc=9.159116415e-01
alter vs dc=9.649237378e-01
alter vb dc=1.017647805e+00
option temp=-31.323164
op
let idx = 161
wrdata C:/Users/udhav/DVD-Project/work/pmos_off_0.out idx i(Vd) i(Vg) i(Vs) i(Vb) @m1[id] @m1[igs] @m1[igd] @m1[igcs] @m1[igcd] @m1[igb] @m1[igidl] @m1[igisl] @m1[isub] @m1[ibd] @m1[ibs]
destroy all
altermod pmos vth0=-4.058727332e-01
altermod pmos toxe=9.891030722e-10
altermod pmos ndep=4.989508137e+18
altermod pmos u0=5.716545008e-03
altermod pmos xj=4.582512071e-09
alter m1 w=3.154060728e-08
alter vd dc=8.764526585e-01
alter vg dc=9.772431081e-01
alter vs dc=2.330827892e-01
alter vb dc=9.772431081e-01
option temp=40.120631
op
let idx = 162
wrdata C:/Users/udhav/DVD-Project/work/pmos_off_0.out idx i(Vd) i(Vg) i(Vs) i(Vb) @m1[id] @m1[igs] @m1[igd] @m1[igcs] @m1[igcd] @m1[igb] @m1[igidl] @m1[igisl] @m1[isub] @m1[ibd] @m1[ibs]
destroy all
altermod pmos vth0=-4.287425414e-01
altermod pmos toxe=1.046851653e-09
altermod pmos ndep=5.624259662e+18
altermod pmos u0=5.924207268e-03
altermod pmos xj=5.001466966e-09
alter m1 w=1.070782440e-07
alter vd dc=0.000000000e+00
alter vg dc=9.248930898e-01
alter vs dc=4.621410301e-01
alter vb dc=9.248930898e-01
option temp=66.615116
op
let idx = 163
wrdata C:/Users/udhav/DVD-Project/work/pmos_off_0.out idx i(Vd) i(Vg) i(Vs) i(Vb) @m1[id] @m1[igs] @m1[igd] @m1[igcs] @m1[igcd] @m1[igb] @m1[igidl] @m1[igisl] @m1[isub] @m1[ibd] @m1[ibs]
destroy all
altermod pmos vth0=-4.071339883e-01
altermod pmos toxe=1.006207542e-09
altermod pmos ndep=5.572979480e+18
altermod pmos u0=5.989776165e-03
altermod pmos xj=4.556060496e-09
alter m1 w=1.135219948e-07
alter vd dc=9.403389666e-01
alter vg dc=9.063464049e-01
alter vs dc=9.845187029e-01
alter vb dc=9.845187029e-01
option temp=112.894071
op
let idx = 164
wrdata C:/Users/udhav/DVD-Project/work/pmos_off_0.out idx i(Vd) i(Vg) i(Vs) i(Vb) @m1[id] @m1[igs] @m1[igd] @m1[igcs] @m1[igcd] @m1[igb] @m1[igidl] @m1[igisl] @m1[isub] @m1[ibd] @m1[ibs]
destroy all
altermod pmos vth0=-4.659453528e-01
altermod pmos toxe=1.061922463e-09
altermod pmos ndep=5.899921692e+18
altermod pmos u0=5.609261554e-03
altermod pmos xj=4.901794463e-09
alter m1 w=6.145709243e-08
alter vd dc=9.056188366e-01
alter vg dc=8.846670843e-01
alter vs dc=4.909502602e-01
alter vb dc=9.195683661e-01
option temp=-39.449987
op
let idx = 165
wrdata C:/Users/udhav/DVD-Project/work/pmos_off_0.out idx i(Vd) i(Vg) i(Vs) i(Vb) @m1[id] @m1[igs] @m1[igd] @m1[igcs] @m1[igcd] @m1[igb] @m1[igidl] @m1[igisl] @m1[isub] @m1[ibd] @m1[ibs]
destroy all
altermod pmos vth0=-4.644236281e-01
altermod pmos toxe=9.815236065e-10
altermod pmos ndep=5.981999989e+18
altermod pmos u0=6.508061678e-03
altermod pmos xj=5.174437323e-09
alter m1 w=1.065629666e-07
alter vd dc=9.787552816e-03
alter vg dc=1.076697844e+00
alter vs dc=6.587486430e-01
alter vb dc=1.076697844e+00
option temp=36.891516
op
let idx = 166
wrdata C:/Users/udhav/DVD-Project/work/pmos_off_0.out idx i(Vd) i(Vg) i(Vs) i(Vb) @m1[id] @m1[igs] @m1[igd] @m1[igcs] @m1[igcd] @m1[igb] @m1[igidl] @m1[igisl] @m1[isub] @m1[ibd] @m1[ibs]
destroy all
altermod pmos vth0=-4.096952534e-01
altermod pmos toxe=9.666586843e-10
altermod pmos ndep=5.871350998e+18
altermod pmos u0=6.310373827e-03
altermod pmos xj=4.642855266e-09
alter m1 w=7.607814241e-08
alter vd dc=5.342903413e-01
alter vg dc=9.796848973e-01
alter vs dc=5.458296951e-03
alter vb dc=9.796848973e-01
option temp=-30.223627
op
let idx = 167
wrdata C:/Users/udhav/DVD-Project/work/pmos_off_0.out idx i(Vd) i(Vg) i(Vs) i(Vb) @m1[id] @m1[igs] @m1[igd] @m1[igcs] @m1[igcd] @m1[igb] @m1[igidl] @m1[igisl] @m1[isub] @m1[ibd] @m1[ibs]
destroy all
altermod pmos vth0=-3.907352957e-01
altermod pmos toxe=1.013204902e-09
altermod pmos ndep=5.830237720e+18
altermod pmos u0=6.371316998e-03
altermod pmos xj=5.138445794e-09
alter m1 w=2.239754528e-08
alter vd dc=1.022614672e+00
alter vg dc=1.084444694e+00
alter vs dc=6.487095714e-05
alter vb dc=1.084444694e+00
option temp=-10.207726
op
let idx = 168
wrdata C:/Users/udhav/DVD-Project/work/pmos_off_0.out idx i(Vd) i(Vg) i(Vs) i(Vb) @m1[id] @m1[igs] @m1[igd] @m1[igcs] @m1[igcd] @m1[igb] @m1[igidl] @m1[igisl] @m1[isub] @m1[ibd] @m1[ibs]
destroy all
altermod pmos vth0=-4.279874025e-01
altermod pmos toxe=9.226794223e-10
altermod pmos ndep=5.368205392e+18
altermod pmos u0=6.066647188e-03
altermod pmos xj=5.430615086e-09
alter m1 w=9.313034413e-08
alter vd dc=0.000000000e+00
alter vg dc=1.025250297e+00
alter vs dc=7.972314458e-01
alter vb dc=1.025250297e+00
option temp=-33.029155
op
let idx = 169
wrdata C:/Users/udhav/DVD-Project/work/pmos_off_0.out idx i(Vd) i(Vg) i(Vs) i(Vb) @m1[id] @m1[igs] @m1[igd] @m1[igcs] @m1[igcd] @m1[igb] @m1[igidl] @m1[igisl] @m1[isub] @m1[ibd] @m1[ibs]
destroy all
altermod pmos vth0=-4.702656061e-01
altermod pmos toxe=9.055084052e-10
altermod pmos ndep=5.668151426e+18
altermod pmos u0=5.623310583e-03
altermod pmos xj=5.298197414e-09
alter m1 w=1.001710793e-07
alter vd dc=9.960100538e-01
alter vg dc=9.960100538e-01
alter vs dc=7.969626986e-01
alter vb dc=9.960100538e-01
option temp=102.206267
op
let idx = 170
wrdata C:/Users/udhav/DVD-Project/work/pmos_off_0.out idx i(Vd) i(Vg) i(Vs) i(Vb) @m1[id] @m1[igs] @m1[igd] @m1[igcs] @m1[igcd] @m1[igb] @m1[igidl] @m1[igisl] @m1[isub] @m1[ibd] @m1[ibs]
destroy all
altermod pmos vth0=-4.019405446e-01
altermod pmos toxe=1.071762130e-09
altermod pmos ndep=4.999872502e+18
altermod pmos u0=6.124566062e-03
altermod pmos xj=4.643265483e-09
alter m1 w=2.748883922e-08
alter vd dc=4.051802056e-01
alter vg dc=9.100504959e-01
alter vs dc=6.556726606e-03
alter vb dc=1.001410215e+00
option temp=-5.161968
op
let idx = 171
wrdata C:/Users/udhav/DVD-Project/work/pmos_off_0.out idx i(Vd) i(Vg) i(Vs) i(Vb) @m1[id] @m1[igs] @m1[igd] @m1[igcs] @m1[igcd] @m1[igb] @m1[igidl] @m1[igisl] @m1[isub] @m1[ibd] @m1[ibs]
destroy all
altermod pmos vth0=-4.690982890e-01
altermod pmos toxe=9.071075351e-10
altermod pmos ndep=5.417406839e+18
altermod pmos u0=5.966869347e-03
altermod pmos xj=5.262271120e-09
alter m1 w=5.978528692e-08
alter vd dc=4.964261135e-01
alter vg dc=9.764540123e-01
alter vs dc=1.394192698e-03
alter vb dc=9.764540123e-01
option temp=15.943248
op
let idx = 172
wrdata C:/Users/udhav/DVD-Project/work/pmos_off_0.out idx i(Vd) i(Vg) i(Vs) i(Vb) @m1[id] @m1[igs] @m1[igd] @m1[igcs] @m1[igcd] @m1[igb] @m1[igidl] @m1[igisl] @m1[isub] @m1[ibd] @m1[ibs]
destroy all
altermod pmos vth0=-4.193933090e-01
altermod pmos toxe=1.014091406e-09
altermod pmos ndep=5.405839602e+18
altermod pmos u0=6.438380234e-03
altermod pmos xj=4.723773533e-09
alter m1 w=6.353394042e-08
alter vd dc=8.179542046e-03
alter vg dc=8.806710899e-01
alter vs dc=1.712206871e-02
alter vb dc=9.572629527e-01
option temp=28.919725
op
let idx = 173
wrdata C:/Users/udhav/DVD-Project/work/pmos_off_0.out idx i(Vd) i(Vg) i(Vs) i(Vb) @m1[id] @m1[igs] @m1[igd] @m1[igcs] @m1[igcd] @m1[igb] @m1[igidl] @m1[igisl] @m1[isub] @m1[ibd] @m1[ibs]
destroy all
altermod pmos vth0=-4.046195561e-01
altermod pmos toxe=9.179433366e-10
altermod pmos ndep=5.350854944e+18
altermod pmos u0=5.794212106e-03
altermod pmos xj=4.579624223e-09
alter m1 w=5.852719511e-08
alter vd dc=8.941237794e-01
alter vg dc=9.294222237e-01
alter vs dc=0.000000000e+00
alter vb dc=9.294222237e-01
option temp=-19.570441
op
let idx = 174
wrdata C:/Users/udhav/DVD-Project/work/pmos_off_0.out idx i(Vd) i(Vg) i(Vs) i(Vb) @m1[id] @m1[igs] @m1[igd] @m1[igcs] @m1[igcd] @m1[igb] @m1[igidl] @m1[igisl] @m1[isub] @m1[ibd] @m1[ibs]
destroy all
altermod pmos vth0=-4.619573299e-01
altermod pmos toxe=9.663156732e-10
altermod pmos ndep=5.475094026e+18
altermod pmos u0=6.168736828e-03
altermod pmos xj=4.623740083e-09
alter m1 w=1.870158060e-08
alter vd dc=5.855679136e-02
alter vg dc=9.113304126e-01
alter vs dc=5.407937600e-01
alter vb dc=1.009890618e+00
option temp=6.522266
op
let idx = 175
wrdata C:/Users/udhav/DVD-Project/work/pmos_off_0.out idx i(Vd) i(Vg) i(Vs) i(Vb) @m1[id] @m1[igs] @m1[igd] @m1[igcs] @m1[igcd] @m1[igb] @m1[igidl] @m1[igisl] @m1[isub] @m1[ibd] @m1[ibs]
destroy all
altermod pmos vth0=-4.243693882e-01
altermod pmos toxe=9.636143129e-10
altermod pmos ndep=5.563610150e+18
altermod pmos u0=6.250383567e-03
altermod pmos xj=4.816818479e-09
alter m1 w=7.756362915e-08
alter vd dc=2.071874782e-01
alter vg dc=1.006743002e+00
alter vs dc=1.006743002e+00
alter vb dc=1.006743002e+00
option temp=96.343107
op
let idx = 176
wrdata C:/Users/udhav/DVD-Project/work/pmos_off_0.out idx i(Vd) i(Vg) i(Vs) i(Vb) @m1[id] @m1[igs] @m1[igd] @m1[igcs] @m1[igcd] @m1[igb] @m1[igidl] @m1[igisl] @m1[isub] @m1[ibd] @m1[ibs]
destroy all
altermod pmos vth0=-4.258950323e-01
altermod pmos toxe=9.254526722e-10
altermod pmos ndep=5.527916870e+18
altermod pmos u0=6.374455420e-03
altermod pmos xj=5.308834142e-09
alter m1 w=9.801510426e-08
alter vd dc=0.000000000e+00
alter vg dc=9.643228837e-01
alter vs dc=2.249273512e-02
alter vb dc=9.643228837e-01
option temp=124.571336
op
let idx = 177
wrdata C:/Users/udhav/DVD-Project/work/pmos_off_0.out idx i(Vd) i(Vg) i(Vs) i(Vb) @m1[id] @m1[igs] @m1[igd] @m1[igcs] @m1[igcd] @m1[igb] @m1[igidl] @m1[igisl] @m1[isub] @m1[ibd] @m1[ibs]
destroy all
altermod pmos vth0=-4.050041359e-01
altermod pmos toxe=9.829458194e-10
altermod pmos ndep=5.419943130e+18
altermod pmos u0=6.157828196e-03
altermod pmos xj=5.200242290e-09
alter m1 w=6.850310915e-08
alter vd dc=9.855285562e-01
alter vg dc=9.986710105e-01
alter vs dc=9.986710105e-01
alter vb dc=9.986710105e-01
option temp=40.273950
op
let idx = 178
wrdata C:/Users/udhav/DVD-Project/work/pmos_off_0.out idx i(Vd) i(Vg) i(Vs) i(Vb) @m1[id] @m1[igs] @m1[igd] @m1[igcs] @m1[igcd] @m1[igb] @m1[igidl] @m1[igisl] @m1[isub] @m1[ibd] @m1[ibs]
destroy all
altermod pmos vth0=-4.492049684e-01
altermod pmos toxe=9.370983413e-10
altermod pmos ndep=5.895164679e+18
altermod pmos u0=5.825411958e-03
altermod pmos xj=5.423272882e-09
alter m1 w=1.057223846e-07
alter vd dc=0.000000000e+00
alter vg dc=8.766144234e-01
alter vs dc=4.458932817e-03
alter vb dc=9.526644732e-01
option temp=-33.589027
op
let idx = 179
wrdata C:/Users/udhav/DVD-Project/work/pmos_off_0.out idx i(Vd) i(Vg) i(Vs) i(Vb) @m1[id] @m1[igs] @m1[igd] @m1[igcs] @m1[igcd] @m1[igb] @m1[igidl] @m1[igisl] @m1[isub] @m1[ibd] @m1[ibs]
destroy all
altermod pmos vth0=-4.238177370e-01
altermod pmos toxe=9.352596956e-10
altermod pmos ndep=5.154684727e+18
altermod pmos u0=5.612757926e-03
altermod pmos xj=4.741514516e-09
alter m1 w=7.757740007e-08
alter vd dc=9.117663574e-01
alter vg dc=9.099159759e-01
alter vs dc=4.176977308e-01
alter vb dc=9.362989123e-01
option temp=-18.347041
op
let idx = 180
wrdata C:/Users/udhav/DVD-Project/work/pmos_off_0.out idx i(Vd) i(Vg) i(Vs) i(Vb) @m1[id] @m1[igs] @m1[igd] @m1[igcs] @m1[igcd] @m1[igb] @m1[igidl] @m1[igisl] @m1[isub] @m1[ibd] @m1[ibs]
destroy all
altermod pmos vth0=-4.368239438e-01
altermod pmos toxe=1.000875516e-09
altermod pmos ndep=5.490927784e+18
altermod pmos u0=5.918534747e-03
altermod pmos xj=4.754883888e-09
alter m1 w=4.015575659e-08
alter vd dc=9.812176302e-01
alter vg dc=1.029832841e+00
alter vs dc=2.330873600e-01
alter vb dc=1.029832841e+00
option temp=-6.501232
op
let idx = 181
wrdata C:/Users/udhav/DVD-Project/work/pmos_off_0.out idx i(Vd) i(Vg) i(Vs) i(Vb) @m1[id] @m1[igs] @m1[igd] @m1[igcs] @m1[igcd] @m1[igb] @m1[igidl] @m1[igisl] @m1[isub] @m1[ibd] @m1[ibs]
destroy all
altermod pmos vth0=-3.998509406e-01
altermod pmos toxe=9.962087549e-10
altermod pmos ndep=5.692446517e+18
altermod pmos u0=5.947066952e-03
altermod pmos xj=4.665431795e-09
alter m1 w=1.048744169e-07
alter vd dc=0.000000000e+00
alter vg dc=9.737950282e-01
alter vs dc=7.194994904e-01
alter vb dc=1.045400306e+00
option temp=60.575012
op
let idx = 182
wrdata C:/Users/udhav/DVD-Project/work/pmos_off_0.out idx i(Vd) i(Vg) i(Vs) i(Vb) @m1[id] @m1[igs] @m1[igd] @m1[igcs] @m1[igcd] @m1[igb] @m1[igidl] @m1[igisl] @m1[isub] @m1[ibd] @m1[ibs]
destroy all
altermod pmos vth0=-4.229662046e-01
altermod pmos toxe=1.088863295e-09
altermod pmos ndep=5.533434291e+18
altermod pmos u0=5.905608794e-03
altermod pmos xj=5.400266772e-09
alter m1 w=1.064904299e-07
alter vd dc=1.088210609e+00
alter vg dc=1.053664393e+00
alter vs dc=1.093778573e+00
alter vb dc=1.093778573e+00
option temp=-36.610156
op
let idx = 183
wrdata C:/Users/udhav/DVD-Project/work/pmos_off_0.out idx i(Vd) i(Vg) i(Vs) i(Vb) @m1[id] @m1[igs] @m1[igd] @m1[igcs] @m1[igcd] @m1[igb] @m1[igidl] @m1[igisl] @m1[isub] @m1[ibd] @m1[ibs]
destroy all
altermod pmos vth0=-4.007115394e-01
altermod pmos toxe=1.016603653e-09
altermod pmos ndep=5.906834840e+18
altermod pmos u0=6.478314444e-03
altermod pmos xj=5.431709553e-09
alter m1 w=6.125409589e-08
alter vd dc=5.591066411e-04
alter vg dc=9.839291534e-01
alter vs dc=0.000000000e+00
alter vb dc=9.839291534e-01
option temp=58.038591
op
let idx = 184
wrdata C:/Users/udhav/DVD-Project/work/pmos_off_0.out idx i(Vd) i(Vg) i(Vs) i(Vb) @m1[id] @m1[igs] @m1[igd] @m1[igcs] @m1[igcd] @m1[igb] @m1[igidl] @m1[igisl] @m1[isub] @m1[ibd] @m1[ibs]
destroy all
altermod pmos vth0=-4.591084802e-01
altermod pmos toxe=9.573472190e-10
altermod pmos ndep=5.994591196e+18
altermod pmos u0=6.368533125e-03
altermod pmos xj=4.876137357e-09
alter m1 w=1.233757034e-07
alter vd dc=9.929314211e-01
alter vg dc=1.020589214e+00
alter vs dc=8.680079162e-01
alter vb dc=1.020589214e+00
option temp=14.741307
op
let idx = 185
wrdata C:/Users/udhav/DVD-Project/work/pmos_off_0.out idx i(Vd) i(Vg) i(Vs) i(Vb) @m1[id] @m1[igs] @m1[igd] @m1[igcs] @m1[igcd] @m1[igb] @m1[igidl] @m1[igisl] @m1[isub] @m1[ibd] @m1[ibs]
destroy all
altermod pmos vth0=-4.296074202e-01
altermod pmos toxe=9.194435646e-10
altermod pmos ndep=5.201592305e+18
altermod pmos u0=5.734843100e-03
altermod pmos xj=4.540650398e-09
alter m1 w=6.315041727e-08
alter vd dc=1.897011548e-01
alter vg dc=1.007560311e+00
alter vs dc=9.833391176e-01
alter vb dc=1.007560311e+00
option temp=40.138510
op
let idx = 186
wrdata C:/Users/udhav/DVD-Project/work/pmos_off_0.out idx i(Vd) i(Vg) i(Vs) i(Vb) @m1[id] @m1[igs] @m1[igd] @m1[igcs] @m1[igcd] @m1[igb] @m1[igidl] @m1[igisl] @m1[isub] @m1[ibd] @m1[ibs]
destroy all
altermod pmos vth0=-4.252258878e-01
altermod pmos toxe=9.294426517e-10
altermod pmos ndep=5.039361951e+18
altermod pmos u0=6.488159050e-03
altermod pmos xj=4.541485539e-09
alter m1 w=1.254814922e-07
alter vd dc=4.405097339e-01
alter vg dc=8.665163724e-01
alter vs dc=9.053484610e-01
alter vb dc=9.053484610e-01
option temp=2.714539
op
let idx = 187
wrdata C:/Users/udhav/DVD-Project/work/pmos_off_0.out idx i(Vd) i(Vg) i(Vs) i(Vb) @m1[id] @m1[igs] @m1[igd] @m1[igcs] @m1[igcd] @m1[igb] @m1[igidl] @m1[igisl] @m1[isub] @m1[ibd] @m1[ibs]
destroy all
altermod pmos vth0=-4.580717985e-01
altermod pmos toxe=1.038598095e-09
altermod pmos ndep=5.712013771e+18
altermod pmos u0=5.672388954e-03
altermod pmos xj=5.095790739e-09
alter m1 w=6.112923811e-08
alter vd dc=3.722500071e-01
alter vg dc=9.020364332e-01
alter vs dc=8.535215994e-01
alter vb dc=9.462352789e-01
option temp=86.809849
op
let idx = 188
wrdata C:/Users/udhav/DVD-Project/work/pmos_off_0.out idx i(Vd) i(Vg) i(Vs) i(Vb) @m1[id] @m1[igs] @m1[igd] @m1[igcs] @m1[igcd] @m1[igb] @m1[igidl] @m1[igisl] @m1[isub] @m1[ibd] @m1[ibs]
destroy all
altermod pmos vth0=-4.048100462e-01
altermod pmos toxe=1.028630730e-09
altermod pmos ndep=5.932367036e+18
altermod pmos u0=6.223886314e-03
altermod pmos xj=4.507424425e-09
alter m1 w=8.309670076e-08
alter vd dc=5.382889148e-01
alter vg dc=9.217377039e-01
alter vs dc=2.190854811e-02
alter vb dc=9.217377039e-01
option temp=104.148064
op
let idx = 189
wrdata C:/Users/udhav/DVD-Project/work/pmos_off_0.out idx i(Vd) i(Vg) i(Vs) i(Vb) @m1[id] @m1[igs] @m1[igd] @m1[igcs] @m1[igcd] @m1[igb] @m1[igidl] @m1[igisl] @m1[isub] @m1[ibd] @m1[ibs]
destroy all
altermod pmos vth0=-3.929326690e-01
altermod pmos toxe=1.091239743e-09
altermod pmos ndep=5.757350096e+18
altermod pmos u0=6.560176250e-03
altermod pmos xj=4.528435203e-09
alter m1 w=1.248700096e-07
alter vd dc=8.649353941e-01
alter vg dc=9.341557565e-01
alter vs dc=3.515993622e-01
alter vb dc=9.341557565e-01
option temp=92.397969
op
let idx = 190
wrdata C:/Users/udhav/DVD-Project/work/pmos_off_0.out idx i(Vd) i(Vg) i(Vs) i(Vb) @m1[id] @m1[igs] @m1[igd] @m1[igcs] @m1[igcd] @m1[igb] @m1[igidl] @m1[igisl] @m1[isub] @m1[ibd] @m1[ibs]
destroy all
altermod pmos vth0=-4.048188533e-01
altermod pmos toxe=1.068918568e-09
altermod pmos ndep=5.607501336e+18
altermod pmos u0=5.854771838e-03
altermod pmos xj=5.025278223e-09
alter m1 w=1.196753706e-07
alter vd dc=9.374305085e-01
alter vg dc=9.458095719e-01
alter vs dc=9.405542029e-01
alter vb dc=9.685542315e-01
option temp=13.187163
op
let idx = 191
wrdata C:/Users/udhav/DVD-Project/work/pmos_off_0.out idx i(Vd) i(Vg) i(Vs) i(Vb) @m1[id] @m1[igs] @m1[igd] @m1[igcs] @m1[igcd] @m1[igb] @m1[igidl] @m1[igisl] @m1[isub] @m1[ibd] @m1[ibs]
destroy all
altermod pmos vth0=-4.331921364e-01
altermod pmos toxe=1.088473182e-09
altermod pmos ndep=5.017958223e+18
altermod pmos u0=5.721825394e-03
altermod pmos xj=4.648187601e-09
alter m1 w=5.908262711e-08
alter vd dc=9.364983007e-01
alter vg dc=9.364983007e-01
alter vs dc=3.313709222e-01
alter vb dc=9.364983007e-01
option temp=21.570506
op
let idx = 192
wrdata C:/Users/udhav/DVD-Project/work/pmos_off_0.out idx i(Vd) i(Vg) i(Vs) i(Vb) @m1[id] @m1[igs] @m1[igd] @m1[igcs] @m1[igcd] @m1[igb] @m1[igidl] @m1[igisl] @m1[isub] @m1[ibd] @m1[ibs]
destroy all
altermod pmos vth0=-4.365778346e-01
altermod pmos toxe=1.012955230e-09
altermod pmos ndep=5.073784380e+18
altermod pmos u0=5.509601507e-03
altermod pmos xj=4.671211375e-09
alter m1 w=5.476292987e-08
alter vd dc=1.751607015e-02
alter vg dc=1.021720138e+00
alter vs dc=4.353214321e-01
alter vb dc=1.064761859e+00
option temp=70.356240
op
let idx = 193
wrdata C:/Users/udhav/DVD-Project/work/pmos_off_0.out idx i(Vd) i(Vg) i(Vs) i(Vb) @m1[id] @m1[igs] @m1[igd] @m1[igcs] @m1[igcd] @m1[igb] @m1[igidl] @m1[igisl] @m1[isub] @m1[ibd] @m1[ibs]
destroy all
altermod pmos vth0=-4.026952294e-01
altermod pmos toxe=1.009017535e-09
altermod pmos ndep=5.995475571e+18
altermod pmos u0=5.539672411e-03
altermod pmos xj=4.518671578e-09
alter m1 w=1.193102244e-07
alter vd dc=0.000000000e+00
alter vg dc=8.955754019e-01
alter vs dc=2.139979484e-02
alter vb dc=9.496072999e-01
option temp=31.608791
op
let idx = 194
wrdata C:/Users/udhav/DVD-Project/work/pmos_off_0.out idx i(Vd) i(Vg) i(Vs) i(Vb) @m1[id] @m1[igs] @m1[igd] @m1[igcs] @m1[igcd] @m1[igb] @m1[igidl] @m1[igisl] @m1[isub] @m1[ibd] @m1[ibs]
destroy all
altermod pmos vth0=-3.950004985e-01
altermod pmos toxe=9.960047903e-10
altermod pmos ndep=5.451009118e+18
altermod pmos u0=5.890395810e-03
altermod pmos xj=5.479284095e-09
alter m1 w=8.626433621e-08
alter vd dc=4.024426072e-01
alter vg dc=1.033278925e+00
alter vs dc=0.000000000e+00
alter vb dc=1.053168011e+00
option temp=116.612094
op
let idx = 195
wrdata C:/Users/udhav/DVD-Project/work/pmos_off_0.out idx i(Vd) i(Vg) i(Vs) i(Vb) @m1[id] @m1[igs] @m1[igd] @m1[igcs] @m1[igcd] @m1[igb] @m1[igidl] @m1[igisl] @m1[isub] @m1[ibd] @m1[ibs]
destroy all
altermod pmos vth0=-4.329338768e-01
altermod pmos toxe=9.684875945e-10
altermod pmos ndep=5.352635001e+18
altermod pmos u0=6.357146637e-03
altermod pmos xj=4.566059753e-09
alter m1 w=2.280270633e-08
alter vd dc=1.654331496e-01
alter vg dc=1.089945609e+00
alter vs dc=1.514353765e-01
alter vb dc=1.089945609e+00
option temp=5.891514
op
let idx = 196
wrdata C:/Users/udhav/DVD-Project/work/pmos_off_0.out idx i(Vd) i(Vg) i(Vs) i(Vb) @m1[id] @m1[igs] @m1[igd] @m1[igcs] @m1[igcd] @m1[igb] @m1[igidl] @m1[igisl] @m1[isub] @m1[ibd] @m1[ibs]
destroy all
altermod pmos vth0=-3.909968580e-01
altermod pmos toxe=1.067216545e-09
altermod pmos ndep=5.998579622e+18
altermod pmos u0=5.452073979e-03
altermod pmos xj=4.620269884e-09
alter m1 w=3.079130251e-08
alter vd dc=7.230393784e-01
alter vg dc=1.033235065e+00
alter vs dc=9.657496352e-03
alter vb dc=1.033235065e+00
option temp=29.825458
op
let idx = 197
wrdata C:/Users/udhav/DVD-Project/work/pmos_off_0.out idx i(Vd) i(Vg) i(Vs) i(Vb) @m1[id] @m1[igs] @m1[igd] @m1[igcs] @m1[igcd] @m1[igb] @m1[igidl] @m1[igisl] @m1[isub] @m1[ibd] @m1[ibs]
destroy all
altermod pmos vth0=-3.955831640e-01
altermod pmos toxe=1.054784183e-09
altermod pmos ndep=6.040225652e+18
altermod pmos u0=6.453496911e-03
altermod pmos xj=5.159016267e-09
alter m1 w=2.058515888e-08
alter vd dc=0.000000000e+00
alter vg dc=9.855455429e-01
alter vs dc=8.962796180e-02
alter vb dc=1.009448662e+00
option temp=43.986552
op
let idx = 198
wrdata C:/Users/udhav/DVD-Project/work/pmos_off_0.out idx i(Vd) i(Vg) i(Vs) i(Vb) @m1[id] @m1[igs] @m1[igd] @m1[igcs] @m1[igcd] @m1[igb] @m1[igidl] @m1[igisl] @m1[isub] @m1[ibd] @m1[ibs]
destroy all
altermod pmos vth0=-4.298904117e-01
altermod pmos toxe=9.833312912e-10
altermod pmos ndep=5.302126014e+18
altermod pmos u0=5.702337581e-03
altermod pmos xj=5.408790990e-09
alter m1 w=1.278030936e-07
alter vd dc=0.000000000e+00
alter vg dc=9.236825368e-01
alter vs dc=2.949114104e-01
alter vb dc=9.891927541e-01
option temp=-29.163024
op
let idx = 199
wrdata C:/Users/udhav/DVD-Project/work/pmos_off_0.out idx i(Vd) i(Vg) i(Vs) i(Vb) @m1[id] @m1[igs] @m1[igd] @m1[igcs] @m1[igcd] @m1[igb] @m1[igidl] @m1[igisl] @m1[isub] @m1[ibd] @m1[ibs]
destroy all
altermod pmos vth0=-4.515090889e-01
altermod pmos toxe=9.646953191e-10
altermod pmos ndep=5.077734430e+18
altermod pmos u0=5.711187162e-03
altermod pmos xj=4.521004939e-09
alter m1 w=9.125657268e-08
alter vd dc=7.988946438e-02
alter vg dc=1.040282205e+00
alter vs dc=0.000000000e+00
alter vb dc=1.096127213e+00
option temp=92.397438
op
let idx = 200
wrdata C:/Users/udhav/DVD-Project/work/pmos_off_0.out idx i(Vd) i(Vg) i(Vs) i(Vb) @m1[id] @m1[igs] @m1[igd] @m1[igcs] @m1[igcd] @m1[igb] @m1[igidl] @m1[igisl] @m1[isub] @m1[ibd] @m1[ibs]
destroy all
altermod pmos vth0=-4.054292412e-01
altermod pmos toxe=1.030715885e-09
altermod pmos ndep=5.555928717e+18
altermod pmos u0=6.442019852e-03
altermod pmos xj=5.185820415e-09
alter m1 w=2.516295028e-08
alter vd dc=5.500991755e-02
alter vg dc=1.022534445e+00
alter vs dc=1.053237452e+00
alter vb dc=1.053237452e+00
option temp=54.896121
op
let idx = 201
wrdata C:/Users/udhav/DVD-Project/work/pmos_off_0.out idx i(Vd) i(Vg) i(Vs) i(Vb) @m1[id] @m1[igs] @m1[igd] @m1[igcs] @m1[igcd] @m1[igb] @m1[igidl] @m1[igisl] @m1[isub] @m1[ibd] @m1[ibs]
destroy all
altermod pmos vth0=-4.149514503e-01
altermod pmos toxe=9.696327548e-10
altermod pmos ndep=5.305208360e+18
altermod pmos u0=5.771556441e-03
altermod pmos xj=4.568009649e-09
alter m1 w=7.592089656e-08
alter vd dc=1.289187226e-01
alter vg dc=9.985204986e-01
alter vs dc=2.588301267e-01
alter vb dc=1.028228578e+00
option temp=121.801972
op
let idx = 202
wrdata C:/Users/udhav/DVD-Project/work/pmos_off_0.out idx i(Vd) i(Vg) i(Vs) i(Vb) @m1[id] @m1[igs] @m1[igd] @m1[igcs] @m1[igcd] @m1[igb] @m1[igidl] @m1[igisl] @m1[isub] @m1[ibd] @m1[ibs]
destroy all
altermod pmos vth0=-4.448884358e-01
altermod pmos toxe=9.454776791e-10
altermod pmos ndep=5.307978763e+18
altermod pmos u0=5.939616696e-03
altermod pmos xj=5.086375858e-09
alter m1 w=7.981640129e-08
alter vd dc=4.895342294e-02
alter vg dc=1.092009825e+00
alter vs dc=7.419885443e-01
alter vb dc=1.092009825e+00
option temp=-6.701846
op
let idx = 203
wrdata C:/Users/udhav/DVD-Project/work/pmos_off_0.out idx i(Vd) i(Vg) i(Vs) i(Vb) @m1[id] @m1[igs] @m1[igd] @m1[igcs] @m1[igcd] @m1[igb] @m1[igidl] @m1[igisl] @m1[isub] @m1[ibd] @m1[ibs]
destroy all
altermod pmos vth0=-4.493709575e-01
altermod pmos toxe=1.069593456e-09
altermod pmos ndep=5.687604211e+18
altermod pmos u0=6.337342544e-03
altermod pmos xj=4.710641622e-09
alter m1 w=5.703253712e-08
alter vd dc=4.030567487e-02
alter vg dc=8.285887290e-01
alter vs dc=4.565711489e-01
alter vb dc=9.087746116e-01
option temp=46.117321
op
let idx = 204
wrdata C:/Users/udhav/DVD-Project/work/pmos_off_0.out idx i(Vd) i(Vg) i(Vs) i(Vb) @m1[id] @m1[igs] @m1[igd] @m1[igcs] @m1[igcd] @m1[igb] @m1[igidl] @m1[igisl] @m1[isub] @m1[ibd] @m1[ibs]
destroy all
altermod pmos vth0=-4.120682371e-01
altermod pmos toxe=1.016808390e-09
altermod pmos ndep=5.845328424e+18
altermod pmos u0=5.910372202e-03
altermod pmos xj=5.156991401e-09
alter m1 w=2.079800297e-08
alter vd dc=3.541441358e-01
alter vg dc=9.357666505e-01
alter vs dc=8.357432401e-01
alter vb dc=1.007784127e+00
option temp=41.014254
op
let idx = 205
wrdata C:/Users/udhav/DVD-Project/work/pmos_off_0.out idx i(Vd) i(Vg) i(Vs) i(Vb) @m1[id] @m1[igs] @m1[igd] @m1[igcs] @m1[igcd] @m1[igb] @m1[igidl] @m1[igisl] @m1[isub] @m1[ibd] @m1[ibs]
destroy all
altermod pmos vth0=-3.944618850e-01
altermod pmos toxe=9.559333317e-10
altermod pmos ndep=5.230663346e+18
altermod pmos u0=6.507999084e-03
altermod pmos xj=4.596793346e-09
alter m1 w=1.656258258e-08
alter vd dc=7.643432658e-01
alter vg dc=9.384680911e-01
alter vs dc=9.355172214e-01
alter vb dc=9.399446270e-01
option temp=25.442482
op
let idx = 206
wrdata C:/Users/udhav/DVD-Project/work/pmos_off_0.out idx i(Vd) i(Vg) i(Vs) i(Vb) @m1[id] @m1[igs] @m1[igd] @m1[igcs] @m1[igcd] @m1[igb] @m1[igidl] @m1[igisl] @m1[isub] @m1[ibd] @m1[ibs]
destroy all
altermod pmos vth0=-4.578376337e-01
altermod pmos toxe=1.089295729e-09
altermod pmos ndep=5.687839681e+18
altermod pmos u0=6.365718539e-03
altermod pmos xj=4.920808497e-09
alter m1 w=1.067217804e-07
alter vd dc=7.288468244e-01
alter vg dc=9.458447619e-01
alter vs dc=8.220038946e-01
alter vb dc=1.046064917e+00
option temp=122.215034
op
let idx = 207
wrdata C:/Users/udhav/DVD-Project/work/pmos_off_0.out idx i(Vd) i(Vg) i(Vs) i(Vb) @m1[id] @m1[igs] @m1[igd] @m1[igcs] @m1[igcd] @m1[igb] @m1[igidl] @m1[igisl] @m1[isub] @m1[ibd] @m1[ibs]
destroy all
altermod pmos vth0=-3.951756662e-01
altermod pmos toxe=1.028520801e-09
altermod pmos ndep=5.989281131e+18
altermod pmos u0=5.935286771e-03
altermod pmos xj=4.851174869e-09
alter m1 w=3.867236221e-08
alter vd dc=3.120591082e-01
alter vg dc=9.475727036e-01
alter vs dc=2.859642802e-01
alter vb dc=1.015670098e+00
option temp=70.363569
op
let idx = 208
wrdata C:/Users/udhav/DVD-Project/work/pmos_off_0.out idx i(Vd) i(Vg) i(Vs) i(Vb) @m1[id] @m1[igs] @m1[igd] @m1[igcs] @m1[igcd] @m1[igb] @m1[igidl] @m1[igisl] @m1[isub] @m1[ibd] @m1[ibs]
destroy all
altermod pmos vth0=-4.732298683e-01
altermod pmos toxe=9.656194326e-10
altermod pmos ndep=5.352886319e+18
altermod pmos u0=6.073825244e-03
altermod pmos xj=4.591614532e-09
alter m1 w=5.888910765e-08
alter vd dc=4.553560760e-02
alter vg dc=9.688818386e-01
alter vs dc=3.136789993e-03
alter vb dc=9.688818386e-01
option temp=75.247794
op
let idx = 209
wrdata C:/Users/udhav/DVD-Project/work/pmos_off_0.out idx i(Vd) i(Vg) i(Vs) i(Vb) @m1[id] @m1[igs] @m1[igd] @m1[igcs] @m1[igcd] @m1[igb] @m1[igidl] @m1[igisl] @m1[isub] @m1[ibd] @m1[ibs]
destroy all
altermod pmos vth0=-4.637338188e-01
altermod pmos toxe=1.028991512e-09
altermod pmos ndep=5.685286425e+18
altermod pmos u0=6.320901594e-03
altermod pmos xj=4.543964691e-09
alter m1 w=6.549440264e-08
alter vd dc=8.963568726e-01
alter vg dc=1.096317011e+00
alter vs dc=1.096913406e+00
alter vb dc=1.096913406e+00
option temp=-2.965774
op
let idx = 210
wrdata C:/Users/udhav/DVD-Project/work/pmos_off_0.out idx i(Vd) i(Vg) i(Vs) i(Vb) @m1[id] @m1[igs] @m1[igd] @m1[igcs] @m1[igcd] @m1[igb] @m1[igidl] @m1[igisl] @m1[isub] @m1[ibd] @m1[ibs]
destroy all
altermod pmos vth0=-4.052849447e-01
altermod pmos toxe=9.151716083e-10
altermod pmos ndep=5.835895211e+18
altermod pmos u0=6.508365412e-03
altermod pmos xj=4.951359968e-09
alter m1 w=1.208894584e-07
alter vd dc=8.660900258e-01
alter vg dc=1.013622814e+00
alter vs dc=1.013622814e+00
alter vb dc=1.013622814e+00
option temp=90.154748
op
let idx = 211
wrdata C:/Users/udhav/DVD-Project/work/pmos_off_0.out idx i(Vd) i(Vg) i(Vs) i(Vb) @m1[id] @m1[igs] @m1[igd] @m1[igcs] @m1[igcd] @m1[igb] @m1[igidl] @m1[igisl] @m1[isub] @m1[ibd] @m1[ibs]
destroy all
altermod pmos vth0=-4.081011570e-01
altermod pmos toxe=9.200061706e-10
altermod pmos ndep=5.076855256e+18
altermod pmos u0=6.109524915e-03
altermod pmos xj=5.437818755e-09
alter m1 w=1.020804028e-07
alter vd dc=3.531919106e-01
alter vg dc=8.928645987e-01
alter vs dc=9.561510509e-01
alter vb dc=9.561510509e-01
option temp=69.082396
op
let idx = 212
wrdata C:/Users/udhav/DVD-Project/work/pmos_off_0.out idx i(Vd) i(Vg) i(Vs) i(Vb) @m1[id] @m1[igs] @m1[igd] @m1[igcs] @m1[igcd] @m1[igb] @m1[igidl] @m1[igisl] @m1[isub] @m1[ibd] @m1[ibs]
destroy all
altermod pmos vth0=-4.149277361e-01
altermod pmos toxe=9.691767703e-10
altermod pmos ndep=5.107572866e+18
altermod pmos u0=5.860575819e-03
altermod pmos xj=4.842868695e-09
alter m1 w=5.940397440e-08
alter vd dc=0.000000000e+00
alter vg dc=9.461298726e-01
alter vs dc=0.000000000e+00
alter vb dc=9.533684283e-01
option temp=53.764448
op
let idx = 213
wrdata C:/Users/udhav/DVD-Project/work/pmos_off_0.out idx i(Vd) i(Vg) i(Vs) i(Vb) @m1[id] @m1[igs] @m1[igd] @m1[igcs] @m1[igcd] @m1[igb] @m1[igidl] @m1[igisl] @m1[isub] @m1[ibd] @m1[ibs]
destroy all
altermod pmos vth0=-4.250939013e-01
altermod pmos toxe=1.022857229e-09
altermod pmos ndep=5.662933260e+18
altermod pmos u0=5.699239034e-03
altermod pmos xj=5.030840448e-09
alter m1 w=7.768925016e-08
alter vd dc=0.000000000e+00
alter vg dc=9.084912389e-01
alter vs dc=4.351690539e-01
alter vb dc=9.084912389e-01
option temp=-31.539974
op
let idx = 214
wrdata C:/Users/udhav/DVD-Project/work/pmos_off_0.out idx i(Vd) i(Vg) i(Vs) i(Vb) @m1[id] @m1[igs] @m1[igd] @m1[igcs] @m1[igcd] @m1[igb] @m1[igidl] @m1[igisl] @m1[isub] @m1[ibd] @m1[ibs]
destroy all
altermod pmos vth0=-4.226601379e-01
altermod pmos toxe=9.795641271e-10
altermod pmos ndep=5.540015749e+18
altermod pmos u0=5.597992678e-03
altermod pmos xj=4.522134685e-09
alter m1 w=8.650715619e-08
alter vd dc=9.355471392e-01
alter vg dc=9.758866799e-01
alter vs dc=3.351136952e-01
alter vb dc=9.758866799e-01
option temp=-8.760642
op
let idx = 215
wrdata C:/Users/udhav/DVD-Project/work/pmos_off_0.out idx i(Vd) i(Vg) i(Vs) i(Vb) @m1[id] @m1[igs] @m1[igd] @m1[igcs] @m1[igcd] @m1[igb] @m1[igidl] @m1[igisl] @m1[isub] @m1[ibd] @m1[ibs]
destroy all
altermod pmos vth0=-4.553469793e-01
altermod pmos toxe=9.078211578e-10
altermod pmos ndep=5.207030008e+18
altermod pmos u0=5.574227665e-03
altermod pmos xj=5.277553042e-09
alter m1 w=1.011425837e-07
alter vd dc=6.833147289e-02
alter vg dc=9.289754538e-01
alter vs dc=9.289754538e-01
alter vb dc=9.289754538e-01
option temp=19.320420
op
let idx = 216
wrdata C:/Users/udhav/DVD-Project/work/pmos_off_0.out idx i(Vd) i(Vg) i(Vs) i(Vb) @m1[id] @m1[igs] @m1[igd] @m1[igcs] @m1[igcd] @m1[igb] @m1[igidl] @m1[igisl] @m1[isub] @m1[ibd] @m1[ibs]
destroy all
altermod pmos vth0=-3.981613021e-01
altermod pmos toxe=1.076468592e-09
altermod pmos ndep=5.365725061e+18
altermod pmos u0=6.062199914e-03
altermod pmos xj=5.186859513e-09
alter m1 w=1.277299084e-07
alter vd dc=1.512488724e-03
alter vg dc=1.008222161e+00
alter vs dc=6.848455794e-01
alter vb dc=1.008222161e+00
option temp=41.085225
op
let idx = 217
wrdata C:/Users/udhav/DVD-Project/work/pmos_off_0.out idx i(Vd) i(Vg) i(Vs) i(Vb) @m1[id] @m1[igs] @m1[igd] @m1[igcs] @m1[igcd] @m1[igb] @m1[igidl] @m1[igisl] @m1[isub] @m1[ibd] @m1[ibs]
destroy all
altermod pmos vth0=-4.150065930e-01
altermod pmos toxe=1.092003457e-09
altermod pmos ndep=5.576770748e+18
altermod pmos u0=6.468040466e-03
altermod pmos xj=4.925686734e-09
alter m1 w=6.256786321e-08
alter vd dc=0.000000000e+00
alter vg dc=8.828189027e-01
alter vs dc=9.223401535e-01
alter vb dc=9.223401535e-01
option temp=55.260816
op
let idx = 218
wrdata C:/Users/udhav/DVD-Project/work/pmos_off_0.out idx i(Vd) i(Vg) i(Vs) i(Vb) @m1[id] @m1[igs] @m1[igd] @m1[igcs] @m1[igcd] @m1[igb] @m1[igidl] @m1[igisl] @m1[isub] @m1[ibd] @m1[ibs]
destroy all
altermod pmos vth0=-4.307475325e-01
altermod pmos toxe=9.685995708e-10
altermod pmos ndep=6.039001044e+18
altermod pmos u0=5.448256004e-03
altermod pmos xj=4.696995099e-09
alter m1 w=8.476400010e-08
alter vd dc=1.017612134e+00
alter vg dc=1.017612134e+00
alter vs dc=2.374087488e-01
alter vb dc=1.017612134e+00
option temp=-21.106035
op
let idx = 219
wrdata C:/Users/udhav/DVD-Project/work/pmos_off_0.out idx i(Vd) i(Vg) i(Vs) i(Vb) @m1[id] @m1[igs] @m1[igd] @m1[igcs] @m1[igcd] @m1[igb] @m1[igidl] @m1[igisl] @m1[isub] @m1[ibd] @m1[ibs]
destroy all
altermod pmos vth0=-4.737849713e-01
altermod pmos toxe=9.860085742e-10
altermod pmos ndep=5.154253548e+18
altermod pmos u0=6.064518033e-03
altermod pmos xj=5.208878047e-09
alter m1 w=1.166263920e-07
alter vd dc=1.004144628e+00
alter vg dc=1.004375677e+00
alter vs dc=3.161446568e-01
alter vb dc=1.004375677e+00
option temp=35.584878
op
let idx = 220
wrdata C:/Users/udhav/DVD-Project/work/pmos_off_0.out idx i(Vd) i(Vg) i(Vs) i(Vb) @m1[id] @m1[igs] @m1[igd] @m1[igcs] @m1[igcd] @m1[igb] @m1[igidl] @m1[igisl] @m1[isub] @m1[ibd] @m1[ibs]
destroy all
altermod pmos vth0=-4.019081691e-01
altermod pmos toxe=1.071872930e-09
altermod pmos ndep=5.095419162e+18
altermod pmos u0=5.913504321e-03
altermod pmos xj=5.040734984e-09
alter m1 w=9.991276467e-08
alter vd dc=3.182063561e-01
alter vg dc=1.099892097e+00
alter vs dc=6.019670333e-05
alter vb dc=1.099892097e+00
option temp=-38.458941
op
let idx = 221
wrdata C:/Users/udhav/DVD-Project/work/pmos_off_0.out idx i(Vd) i(Vg) i(Vs) i(Vb) @m1[id] @m1[igs] @m1[igd] @m1[igcs] @m1[igcd] @m1[igb] @m1[igidl] @m1[igisl] @m1[isub] @m1[ibd] @m1[ibs]
destroy all
altermod pmos vth0=-3.902493143e-01
altermod pmos toxe=9.193026511e-10
altermod pmos ndep=5.204467991e+18
altermod pmos u0=6.457909869e-03
altermod pmos xj=5.465959160e-09
alter m1 w=6.455236474e-08
alter vd dc=1.031305421e+00
alter vg dc=1.010453006e+00
alter vs dc=0.000000000e+00
alter vb dc=1.031305421e+00
option temp=-29.942620
op
let idx = 222
wrdata C:/Users/udhav/DVD-Project/work/pmos_off_0.out idx i(Vd) i(Vg) i(Vs) i(Vb) @m1[id] @m1[igs] @m1[igd] @m1[igcs] @m1[igcd] @m1[igb] @m1[igidl] @m1[igisl] @m1[isub] @m1[ibd] @m1[ibs]
destroy all
altermod pmos vth0=-4.547132222e-01
altermod pmos toxe=1.061225933e-09
altermod pmos ndep=5.390422466e+18
altermod pmos u0=5.502152416e-03
altermod pmos xj=4.726519867e-09
alter m1 w=1.168876067e-07
alter vd dc=1.062423149e+00
alter vg dc=9.811485062e-01
alter vs dc=1.040556025e+00
alter vb dc=1.062423149e+00
option temp=77.916714
op
let idx = 223
wrdata C:/Users/udhav/DVD-Project/work/pmos_off_0.out idx i(Vd) i(Vg) i(Vs) i(Vb) @m1[id] @m1[igs] @m1[igd] @m1[igcs] @m1[igcd] @m1[igb] @m1[igidl] @m1[igisl] @m1[isub] @m1[ibd] @m1[ibs]
destroy all
altermod pmos vth0=-4.654385597e-01
altermod pmos toxe=1.099858411e-09
altermod pmos ndep=5.982327526e+18
altermod pmos u0=6.397636752e-03
altermod pmos xj=4.561376722e-09
alter m1 w=4.090126605e-08
alter vd dc=5.829910955e-01
alter vg dc=1.074353142e+00
alter vs dc=6.028221721e-01
alter vb dc=1.074353142e+00
option temp=9.107655
op
let idx = 224
wrdata C:/Users/udhav/DVD-Project/work/pmos_off_0.out idx i(Vd) i(Vg) i(Vs) i(Vb) @m1[id] @m1[igs] @m1[igd] @m1[igcs] @m1[igcd] @m1[igb] @m1[igidl] @m1[igisl] @m1[isub] @m1[ibd] @m1[ibs]
destroy all
altermod pmos vth0=-3.995806842e-01
altermod pmos toxe=1.058996134e-09
altermod pmos ndep=5.086851127e+18
altermod pmos u0=5.942912825e-03
altermod pmos xj=4.958899003e-09
alter m1 w=2.608646866e-08
alter vd dc=1.035540645e+00
alter vg dc=1.035540645e+00
alter vs dc=4.067593447e-03
alter vb dc=1.035540645e+00
option temp=-21.736470
op
let idx = 225
wrdata C:/Users/udhav/DVD-Project/work/pmos_off_0.out idx i(Vd) i(Vg) i(Vs) i(Vb) @m1[id] @m1[igs] @m1[igd] @m1[igcs] @m1[igcd] @m1[igb] @m1[igidl] @m1[igisl] @m1[isub] @m1[ibd] @m1[ibs]
destroy all
altermod pmos vth0=-4.728734900e-01
altermod pmos toxe=9.471037944e-10
altermod pmos ndep=5.972076338e+18
altermod pmos u0=5.946409986e-03
altermod pmos xj=5.077399344e-09
alter m1 w=9.115116956e-08
alter vd dc=4.440044505e-01
alter vg dc=1.098015254e+00
alter vs dc=1.886534368e-01
alter vb dc=1.098015254e+00
option temp=31.382655
op
let idx = 226
wrdata C:/Users/udhav/DVD-Project/work/pmos_off_0.out idx i(Vd) i(Vg) i(Vs) i(Vb) @m1[id] @m1[igs] @m1[igd] @m1[igcs] @m1[igcd] @m1[igb] @m1[igidl] @m1[igisl] @m1[isub] @m1[ibd] @m1[ibs]
destroy all
altermod pmos vth0=-4.291047199e-01
altermod pmos toxe=9.785694548e-10
altermod pmos ndep=5.949787088e+18
altermod pmos u0=6.162855086e-03
altermod pmos xj=5.301268851e-09
alter m1 w=7.852744014e-08
alter vd dc=0.000000000e+00
alter vg dc=1.098706528e+00
alter vs dc=1.033647048e+00
alter vb dc=1.098782557e+00
option temp=42.478029
op
let idx = 227
wrdata C:/Users/udhav/DVD-Project/work/pmos_off_0.out idx i(Vd) i(Vg) i(Vs) i(Vb) @m1[id] @m1[igs] @m1[igd] @m1[igcs] @m1[igcd] @m1[igb] @m1[igidl] @m1[igisl] @m1[isub] @m1[ibd] @m1[ibs]
destroy all
altermod pmos vth0=-3.986204313e-01
altermod pmos toxe=1.014962808e-09
altermod pmos ndep=5.422768344e+18
altermod pmos u0=5.835693362e-03
altermod pmos xj=4.505246511e-09
alter m1 w=4.589714507e-08
alter vd dc=0.000000000e+00
alter vg dc=8.927261099e-01
alter vs dc=9.868246269e-01
alter vb dc=9.868916985e-01
option temp=-30.198696
op
let idx = 228
wrdata C:/Users/udhav/DVD-Project/work/pmos_off_0.out idx i(Vd) i(Vg) i(Vs) i(Vb) @m1[id] @m1[igs] @m1[igd] @m1[igcs] @m1[igcd] @m1[igb] @m1[igidl] @m1[igisl] @m1[isub] @m1[ibd] @m1[ibs]
destroy all
altermod pmos vth0=-4.268318338e-01
altermod pmos toxe=1.039909128e-09
altermod pmos ndep=5.748222891e+18
altermod pmos u0=6.144835493e-03
altermod pmos xj=5.283167419e-09
alter m1 w=8.711467758e-08
alter vd dc=0.000000000e+00
alter vg dc=9.062113318e-01
alter vs dc=0.000000000e+00
alter vb dc=9.062113318e-01
option temp=106.582412
op
let idx = 229
wrdata C:/Users/udhav/DVD-Project/work/pmos_off_0.out idx i(Vd) i(Vg) i(Vs) i(Vb) @m1[id] @m1[igs] @m1[igd] @m1[igcs] @m1[igcd] @m1[igb] @m1[igidl] @m1[igisl] @m1[isub] @m1[ibd] @m1[ibs]
destroy all
altermod pmos vth0=-4.196862858e-01
altermod pmos toxe=1.031665288e-09
altermod pmos ndep=5.610237539e+18
altermod pmos u0=6.307252221e-03
altermod pmos xj=4.915923200e-09
alter m1 w=9.992309506e-08
alter vd dc=9.196774563e-01
alter vg dc=9.095896099e-01
alter vs dc=9.196774563e-01
alter vb dc=9.196774563e-01
option temp=75.660216
op
let idx = 230
wrdata C:/Users/udhav/DVD-Project/work/pmos_off_0.out idx i(Vd) i(Vg) i(Vs) i(Vb) @m1[id] @m1[igs] @m1[igd] @m1[igcs] @m1[igcd] @m1[igb] @m1[igidl] @m1[igisl] @m1[isub] @m1[ibd] @m1[ibs]
destroy all
altermod pmos vth0=-4.406669998e-01
altermod pmos toxe=9.897846698e-10
altermod pmos ndep=5.622747389e+18
altermod pmos u0=5.594300259e-03
altermod pmos xj=4.662494921e-09
alter m1 w=8.611564559e-08
alter vd dc=4.742174698e-01
alter vg dc=1.035697305e+00
alter vs dc=1.035697305e+00
alter vb dc=1.035697305e+00
option temp=53.127502
op
let idx = 231
wrdata C:/Users/udhav/DVD-Project/work/pmos_off_0.out idx i(Vd) i(Vg) i(Vs) i(Vb) @m1[id] @m1[igs] @m1[igd] @m1[igcs] @m1[igcd] @m1[igb] @m1[igidl] @m1[igisl] @m1[isub] @m1[ibd] @m1[ibs]
destroy all
altermod pmos vth0=-4.414119664e-01
altermod pmos toxe=1.064292450e-09
altermod pmos ndep=5.072358047e+18
altermod pmos u0=5.641198411e-03
altermod pmos xj=5.184519541e-09
alter m1 w=1.252458528e-07
alter vd dc=9.942515216e-01
alter vg dc=1.070643378e+00
alter vs dc=1.072618965e+00
alter vb dc=1.072618965e+00
option temp=-36.932101
op
let idx = 232
wrdata C:/Users/udhav/DVD-Project/work/pmos_off_0.out idx i(Vd) i(Vg) i(Vs) i(Vb) @m1[id] @m1[igs] @m1[igd] @m1[igcs] @m1[igcd] @m1[igb] @m1[igidl] @m1[igisl] @m1[isub] @m1[ibd] @m1[ibs]
destroy all
altermod pmos vth0=-4.145303638e-01
altermod pmos toxe=1.074739885e-09
altermod pmos ndep=5.177909916e+18
altermod pmos u0=5.526121297e-03
altermod pmos xj=4.841924608e-09
alter m1 w=5.213569250e-08
alter vd dc=1.097356035e+00
alter vg dc=1.029059550e+00
alter vs dc=1.095585654e+00
alter vb dc=1.097356035e+00
option temp=-5.685750
op
let idx = 233
wrdata C:/Users/udhav/DVD-Project/work/pmos_off_0.out idx i(Vd) i(Vg) i(Vs) i(Vb) @m1[id] @m1[igs] @m1[igd] @m1[igcs] @m1[igcd] @m1[igb] @m1[igidl] @m1[igisl] @m1[isub] @m1[ibd] @m1[ibs]
destroy all
altermod pmos vth0=-4.126148748e-01
altermod pmos toxe=1.029930255e-09
altermod pmos ndep=5.794486012e+18
altermod pmos u0=6.115983833e-03
altermod pmos xj=4.910483491e-09
alter m1 w=8.960744587e-08
alter vd dc=1.082764745e-01
alter vg dc=8.421067561e-01
alter vs dc=9.299484593e-01
alter vb dc=9.318617900e-01
option temp=61.011883
op
let idx = 234
wrdata C:/Users/udhav/DVD-Project/work/pmos_off_0.out idx i(Vd) i(Vg) i(Vs) i(Vb) @m1[id] @m1[igs] @m1[igd] @m1[igcs] @m1[igcd] @m1[igb] @m1[igidl] @m1[igisl] @m1[isub] @m1[ibd] @m1[ibs]
destroy all
altermod pmos vth0=-4.168072821e-01
altermod pmos toxe=1.004525952e-09
altermod pmos ndep=5.599941441e+18
altermod pmos u0=6.202594320e-03
altermod pmos xj=4.725724111e-09
alter m1 w=6.226149244e-08
alter vd dc=9.100456837e-01
alter vg dc=9.914747996e-01
alter vs dc=5.953550813e-01
alter vb dc=1.007890807e+00
option temp=-24.667145
op
let idx = 235
wrdata C:/Users/udhav/DVD-Project/work/pmos_off_0.out idx i(Vd) i(Vg) i(Vs) i(Vb) @m1[id] @m1[igs] @m1[igd] @m1[igcs] @m1[igcd] @m1[igb] @m1[igidl] @m1[igisl] @m1[isub] @m1[ibd] @m1[ibs]
destroy all
altermod pmos vth0=-4.219066494e-01
altermod pmos toxe=9.214473613e-10
altermod pmos ndep=5.751881442e+18
altermod pmos u0=5.689725843e-03
altermod pmos xj=5.151614632e-09
alter m1 w=1.038380113e-07
alter vd dc=9.804676741e-01
alter vg dc=1.062341198e+00
alter vs dc=1.077438349e+00
alter vb dc=1.077438349e+00
option temp=105.986639
op
let idx = 236
wrdata C:/Users/udhav/DVD-Project/work/pmos_off_0.out idx i(Vd) i(Vg) i(Vs) i(Vb) @m1[id] @m1[igs] @m1[igd] @m1[igcs] @m1[igcd] @m1[igb] @m1[igidl] @m1[igisl] @m1[isub] @m1[ibd] @m1[ibs]
destroy all
altermod pmos vth0=-4.635005688e-01
altermod pmos toxe=9.295043907e-10
altermod pmos ndep=5.433828844e+18
altermod pmos u0=5.533489334e-03
altermod pmos xj=5.034106590e-09
alter m1 w=2.370047472e-08
alter vd dc=1.115325150e-01
alter vg dc=9.020556027e-01
alter vs dc=2.220594725e-01
alter vb dc=9.537250589e-01
option temp=64.563186
op
let idx = 237
wrdata C:/Users/udhav/DVD-Project/work/pmos_off_0.out idx i(Vd) i(Vg) i(Vs) i(Vb) @m1[id] @m1[igs] @m1[igd] @m1[igcs] @m1[igcd] @m1[igb] @m1[igidl] @m1[igisl] @m1[isub] @m1[ibd] @m1[ibs]
destroy all
altermod pmos vth0=-4.574053874e-01
altermod pmos toxe=9.846982965e-10
altermod pmos ndep=5.429950906e+18
altermod pmos u0=6.302439425e-03
altermod pmos xj=4.718800483e-09
alter m1 w=1.033205662e-07
alter vd dc=5.975541401e-01
alter vg dc=1.006093609e+00
alter vs dc=1.061322172e+00
alter vb dc=1.067989506e+00
option temp=98.184035
op
let idx = 238
wrdata C:/Users/udhav/DVD-Project/work/pmos_off_0.out idx i(Vd) i(Vg) i(Vs) i(Vb) @m1[id] @m1[igs] @m1[igd] @m1[igcs] @m1[igcd] @m1[igb] @m1[igidl] @m1[igisl] @m1[isub] @m1[ibd] @m1[ibs]
destroy all
altermod pmos vth0=-4.164124781e-01
altermod pmos toxe=1.087425465e-09
altermod pmos ndep=5.995080190e+18
altermod pmos u0=6.465618721e-03
altermod pmos xj=5.247458316e-09
alter m1 w=4.131206882e-08
alter vd dc=7.631246751e-01
alter vg dc=8.941539453e-01
alter vs dc=1.304401890e-01
alter vb dc=9.550228554e-01
option temp=105.913800
op
let idx = 239
wrdata C:/Users/udhav/DVD-Project/work/pmos_off_0.out idx i(Vd) i(Vg) i(Vs) i(Vb) @m1[id] @m1[igs] @m1[igd] @m1[igcs] @m1[igcd] @m1[igb] @m1[igidl] @m1[igisl] @m1[isub] @m1[ibd] @m1[ibs]
destroy all
altermod pmos vth0=-3.951038801e-01
altermod pmos toxe=9.808080282e-10
altermod pmos ndep=5.557216575e+18
altermod pmos u0=6.556132980e-03
altermod pmos xj=5.111141188e-09
alter m1 w=1.192018174e-07
alter vd dc=6.043209710e-01
alter vg dc=9.307781395e-01
alter vs dc=9.396074108e-01
alter vb dc=9.396074108e-01
option temp=-17.007985
op
let idx = 240
wrdata C:/Users/udhav/DVD-Project/work/pmos_off_0.out idx i(Vd) i(Vg) i(Vs) i(Vb) @m1[id] @m1[igs] @m1[igd] @m1[igcs] @m1[igcd] @m1[igb] @m1[igidl] @m1[igisl] @m1[isub] @m1[ibd] @m1[ibs]
destroy all
altermod pmos vth0=-4.593581814e-01
altermod pmos toxe=1.066428695e-09
altermod pmos ndep=5.181697255e+18
altermod pmos u0=6.228914911e-03
altermod pmos xj=5.373435424e-09
alter m1 w=1.011905969e-07
alter vd dc=9.860170594e-01
alter vg dc=1.003522049e+00
alter vs dc=0.000000000e+00
alter vb dc=1.003522049e+00
option temp=90.047723
op
let idx = 241
wrdata C:/Users/udhav/DVD-Project/work/pmos_off_0.out idx i(Vd) i(Vg) i(Vs) i(Vb) @m1[id] @m1[igs] @m1[igd] @m1[igcs] @m1[igcd] @m1[igb] @m1[igidl] @m1[igisl] @m1[isub] @m1[ibd] @m1[ibs]
destroy all
altermod pmos vth0=-4.210239019e-01
altermod pmos toxe=1.049422129e-09
altermod pmos ndep=5.820824562e+18
altermod pmos u0=6.177325187e-03
altermod pmos xj=4.933908506e-09
alter m1 w=1.127745264e-07
alter vd dc=1.640107750e-01
alter vg dc=1.064894716e+00
alter vs dc=7.670462376e-01
alter vb dc=1.064894716e+00
option temp=34.813840
op
let idx = 242
wrdata C:/Users/udhav/DVD-Project/work/pmos_off_0.out idx i(Vd) i(Vg) i(Vs) i(Vb) @m1[id] @m1[igs] @m1[igd] @m1[igcs] @m1[igcd] @m1[igb] @m1[igidl] @m1[igisl] @m1[isub] @m1[ibd] @m1[ibs]
destroy all
altermod pmos vth0=-4.388097134e-01
altermod pmos toxe=9.824324890e-10
altermod pmos ndep=4.996050067e+18
altermod pmos u0=6.254431204e-03
altermod pmos xj=5.348575128e-09
alter m1 w=3.561896963e-08
alter vd dc=5.703955506e-01
alter vg dc=9.490772231e-01
alter vs dc=3.337909733e-03
alter vb dc=9.860969609e-01
option temp=28.341682
op
let idx = 243
wrdata C:/Users/udhav/DVD-Project/work/pmos_off_0.out idx i(Vd) i(Vg) i(Vs) i(Vb) @m1[id] @m1[igs] @m1[igd] @m1[igcs] @m1[igcd] @m1[igb] @m1[igidl] @m1[igisl] @m1[isub] @m1[ibd] @m1[ibs]
destroy all
altermod pmos vth0=-4.228189158e-01
altermod pmos toxe=9.676163412e-10
altermod pmos ndep=5.948620323e+18
altermod pmos u0=6.038698815e-03
altermod pmos xj=5.108471153e-09
alter m1 w=2.500090004e-08
alter vd dc=2.940887987e-01
alter vg dc=1.048860446e+00
alter vs dc=1.048860446e+00
alter vb dc=1.048860446e+00
option temp=69.152624
op
let idx = 244
wrdata C:/Users/udhav/DVD-Project/work/pmos_off_0.out idx i(Vd) i(Vg) i(Vs) i(Vb) @m1[id] @m1[igs] @m1[igd] @m1[igcs] @m1[igcd] @m1[igb] @m1[igidl] @m1[igisl] @m1[isub] @m1[ibd] @m1[ibs]
destroy all
altermod pmos vth0=-4.444092150e-01
altermod pmos toxe=9.144486962e-10
altermod pmos ndep=5.939068364e+18
altermod pmos u0=5.823668633e-03
altermod pmos xj=5.036519293e-09
alter m1 w=7.111205629e-08
alter vd dc=7.207499242e-01
alter vg dc=9.714980350e-01
alter vs dc=1.135682691e-01
alter vb dc=9.714980350e-01
option temp=123.016333
op
let idx = 245
wrdata C:/Users/udhav/DVD-Project/work/pmos_off_0.out idx i(Vd) i(Vg) i(Vs) i(Vb) @m1[id] @m1[igs] @m1[igd] @m1[igcs] @m1[igcd] @m1[igb] @m1[igidl] @m1[igisl] @m1[isub] @m1[ibd] @m1[ibs]
destroy all
altermod pmos vth0=-4.560533935e-01
altermod pmos toxe=9.934065574e-10
altermod pmos ndep=5.891155827e+18
altermod pmos u0=5.749059097e-03
altermod pmos xj=4.874417198e-09
alter m1 w=8.519232575e-08
alter vd dc=9.318056337e-01
alter vg dc=9.204950757e-01
alter vs dc=8.156155700e-01
alter vb dc=9.473255179e-01
option temp=116.526876
op
let idx = 246
wrdata C:/Users/udhav/DVD-Project/work/pmos_off_0.out idx i(Vd) i(Vg) i(Vs) i(Vb) @m1[id] @m1[igs] @m1[igd] @m1[igcs] @m1[igcd] @m1[igb] @m1[igidl] @m1[igisl] @m1[isub] @m1[ibd] @m1[ibs]
destroy all
altermod pmos vth0=-4.073369198e-01
altermod pmos toxe=1.092793803e-09
altermod pmos ndep=5.088776199e+18
altermod pmos u0=5.965064541e-03
altermod pmos xj=5.055546464e-09
alter m1 w=5.903964630e-08
alter vd dc=1.021549269e+00
alter vg dc=1.029532132e+00
alter vs dc=0.000000000e+00
alter vb dc=1.029532132e+00
option temp=48.351999
op
let idx = 247
wrdata C:/Users/udhav/DVD-Project/work/pmos_off_0.out idx i(Vd) i(Vg) i(Vs) i(Vb) @m1[id] @m1[igs] @m1[igd] @m1[igcs] @m1[igcd] @m1[igb] @m1[igidl] @m1[igisl] @m1[isub] @m1[ibd] @m1[ibs]
destroy all
altermod pmos vth0=-4.444280260e-01
altermod pmos toxe=1.006577910e-09
altermod pmos ndep=5.626878960e+18
altermod pmos u0=5.789395843e-03
altermod pmos xj=5.341944939e-09
alter m1 w=5.986818515e-08
alter vd dc=1.099366803e+00
alter vg dc=1.073209268e+00
alter vs dc=4.570970617e-01
alter vb dc=1.099366803e+00
option temp=87.367950
op
let idx = 248
wrdata C:/Users/udhav/DVD-Project/work/pmos_off_0.out idx i(Vd) i(Vg) i(Vs) i(Vb) @m1[id] @m1[igs] @m1[igd] @m1[igcs] @m1[igcd] @m1[igb] @m1[igidl] @m1[igisl] @m1[isub] @m1[ibd] @m1[ibs]
destroy all
altermod pmos vth0=-4.048900683e-01
altermod pmos toxe=9.413904459e-10
altermod pmos ndep=5.971170373e+18
altermod pmos u0=6.583474797e-03
altermod pmos xj=5.136067185e-09
alter m1 w=8.467876001e-08
alter vd dc=5.064933806e-02
alter vg dc=9.117165928e-01
alter vs dc=8.741649854e-01
alter vb dc=9.529259944e-01
option temp=79.959064
op
let idx = 249
wrdata C:/Users/udhav/DVD-Project/work/pmos_off_0.out idx i(Vd) i(Vg) i(Vs) i(Vb) @m1[id] @m1[igs] @m1[igd] @m1[igcs] @m1[igcd] @m1[igb] @m1[igidl] @m1[igisl] @m1[isub] @m1[ibd] @m1[ibs]
destroy all
altermod pmos vth0=-3.881088920e-01
altermod pmos toxe=1.069762549e-09
altermod pmos ndep=6.046605204e+18
altermod pmos u0=6.542418931e-03
altermod pmos xj=5.007143229e-09
alter m1 w=7.449590178e-08
alter vd dc=1.301369445e-01
alter vg dc=9.987221543e-01
alter vs dc=5.308333936e-03
alter vb dc=9.987221543e-01
option temp=45.699680
op
let idx = 250
wrdata C:/Users/udhav/DVD-Project/work/pmos_off_0.out idx i(Vd) i(Vg) i(Vs) i(Vb) @m1[id] @m1[igs] @m1[igd] @m1[igcs] @m1[igcd] @m1[igb] @m1[igidl] @m1[igisl] @m1[isub] @m1[ibd] @m1[ibs]
destroy all
altermod pmos vth0=-4.380345341e-01
altermod pmos toxe=1.039486639e-09
altermod pmos ndep=5.677601950e+18
altermod pmos u0=5.467098227e-03
altermod pmos xj=4.937645002e-09
alter m1 w=2.908454899e-08
alter vd dc=8.806541740e-01
alter vg dc=9.110586124e-01
alter vs dc=1.169080618e-01
alter vb dc=9.110586124e-01
option temp=70.101871
op
let idx = 251
wrdata C:/Users/udhav/DVD-Project/work/pmos_off_0.out idx i(Vd) i(Vg) i(Vs) i(Vb) @m1[id] @m1[igs] @m1[igd] @m1[igcs] @m1[igcd] @m1[igb] @m1[igidl] @m1[igisl] @m1[isub] @m1[ibd] @m1[ibs]
destroy all
altermod pmos vth0=-4.550977040e-01
altermod pmos toxe=1.032073617e-09
altermod pmos ndep=6.033768088e+18
altermod pmos u0=5.523115480e-03
altermod pmos xj=5.370279506e-09
alter m1 w=6.530142142e-08
alter vd dc=8.891768244e-01
alter vg dc=9.425081781e-01
alter vs dc=9.585418009e-01
alter vb dc=9.585418009e-01
option temp=75.970501
op
let idx = 252
wrdata C:/Users/udhav/DVD-Project/work/pmos_off_0.out idx i(Vd) i(Vg) i(Vs) i(Vb) @m1[id] @m1[igs] @m1[igd] @m1[igcs] @m1[igcd] @m1[igb] @m1[igidl] @m1[igisl] @m1[isub] @m1[ibd] @m1[ibs]
destroy all
altermod pmos vth0=-4.498353617e-01
altermod pmos toxe=1.091104650e-09
altermod pmos ndep=5.025593721e+18
altermod pmos u0=6.077090066e-03
altermod pmos xj=4.699532418e-09
alter m1 w=8.887848446e-08
alter vd dc=7.471986077e-01
alter vg dc=9.193309634e-01
alter vs dc=1.046469751e-01
alter vb dc=9.974340703e-01
option temp=98.024810
op
let idx = 253
wrdata C:/Users/udhav/DVD-Project/work/pmos_off_0.out idx i(Vd) i(Vg) i(Vs) i(Vb) @m1[id] @m1[igs] @m1[igd] @m1[igcs] @m1[igcd] @m1[igb] @m1[igidl] @m1[igisl] @m1[isub] @m1[ibd] @m1[ibs]
destroy all
altermod pmos vth0=-4.346205988e-01
altermod pmos toxe=9.013653553e-10
altermod pmos ndep=5.125955287e+18
altermod pmos u0=6.015686629e-03
altermod pmos xj=5.279721705e-09
alter m1 w=7.481017729e-08
alter vd dc=1.007389975e+00
alter vg dc=9.474202958e-01
alter vs dc=7.284225847e-01
alter vb dc=1.007389975e+00
option temp=-6.231100
op
let idx = 254
wrdata C:/Users/udhav/DVD-Project/work/pmos_off_0.out idx i(Vd) i(Vg) i(Vs) i(Vb) @m1[id] @m1[igs] @m1[igd] @m1[igcs] @m1[igcd] @m1[igb] @m1[igidl] @m1[igisl] @m1[isub] @m1[ibd] @m1[ibs]
destroy all
altermod pmos vth0=-4.433379540e-01
altermod pmos toxe=1.087248050e-09
altermod pmos ndep=5.339718538e+18
altermod pmos u0=5.678046141e-03
altermod pmos xj=5.366923980e-09
alter m1 w=9.476194091e-08
alter vd dc=0.000000000e+00
alter vg dc=8.450239711e-01
alter vs dc=8.626744279e-01
alter vb dc=9.354821169e-01
option temp=75.546914
op
let idx = 255
wrdata C:/Users/udhav/DVD-Project/work/pmos_off_0.out idx i(Vd) i(Vg) i(Vs) i(Vb) @m1[id] @m1[igs] @m1[igd] @m1[igcs] @m1[igcd] @m1[igb] @m1[igidl] @m1[igisl] @m1[isub] @m1[ibd] @m1[ibs]
destroy all
altermod pmos vth0=-4.452463900e-01
altermod pmos toxe=9.471961064e-10
altermod pmos ndep=5.281115639e+18
altermod pmos u0=5.697309318e-03
altermod pmos xj=4.806300138e-09
alter m1 w=1.803140154e-08
alter vd dc=9.123584733e-01
alter vg dc=9.347511362e-01
alter vs dc=9.152829402e-01
alter vb dc=9.347511362e-01
option temp=102.123242
op
let idx = 256
wrdata C:/Users/udhav/DVD-Project/work/pmos_off_0.out idx i(Vd) i(Vg) i(Vs) i(Vb) @m1[id] @m1[igs] @m1[igd] @m1[igcs] @m1[igcd] @m1[igb] @m1[igidl] @m1[igisl] @m1[isub] @m1[ibd] @m1[ibs]
destroy all
altermod pmos vth0=-4.392491278e-01
altermod pmos toxe=1.038937219e-09
altermod pmos ndep=6.047196359e+18
altermod pmos u0=6.048388533e-03
altermod pmos xj=5.124475763e-09
alter m1 w=1.107919630e-07
alter vd dc=3.251100152e-01
alter vg dc=9.599862323e-01
alter vs dc=9.599862323e-01
alter vb dc=9.599862323e-01
option temp=-27.485542
op
let idx = 257
wrdata C:/Users/udhav/DVD-Project/work/pmos_off_0.out idx i(Vd) i(Vg) i(Vs) i(Vb) @m1[id] @m1[igs] @m1[igd] @m1[igcs] @m1[igcd] @m1[igb] @m1[igidl] @m1[igisl] @m1[isub] @m1[ibd] @m1[ibs]
destroy all
altermod pmos vth0=-4.310804451e-01
altermod pmos toxe=1.035533016e-09
altermod pmos ndep=4.977332573e+18
altermod pmos u0=5.938479763e-03
altermod pmos xj=4.714243552e-09
alter m1 w=7.694870485e-08
alter vd dc=5.046220639e-01
alter vg dc=1.023012736e+00
alter vs dc=1.023012736e+00
alter vb dc=1.023012736e+00
option temp=69.396961
op
let idx = 258
wrdata C:/Users/udhav/DVD-Project/work/pmos_off_0.out idx i(Vd) i(Vg) i(Vs) i(Vb) @m1[id] @m1[igs] @m1[igd] @m1[igcs] @m1[igcd] @m1[igb] @m1[igidl] @m1[igisl] @m1[isub] @m1[ibd] @m1[ibs]
destroy all
altermod pmos vth0=-4.006588994e-01
altermod pmos toxe=9.662008428e-10
altermod pmos ndep=5.667659157e+18
altermod pmos u0=6.055655961e-03
altermod pmos xj=5.013228540e-09
alter m1 w=9.260885004e-08
alter vd dc=1.010251722e+00
alter vg dc=1.010251722e+00
alter vs dc=7.927158436e-01
alter vb dc=1.010251722e+00
option temp=112.120811
op
let idx = 259
wrdata C:/Users/udhav/DVD-Project/work/pmos_off_0.out idx i(Vd) i(Vg) i(Vs) i(Vb) @m1[id] @m1[igs] @m1[igd] @m1[igcs] @m1[igcd] @m1[igb] @m1[igidl] @m1[igisl] @m1[isub] @m1[ibd] @m1[ibs]
destroy all
altermod pmos vth0=-4.668886912e-01
altermod pmos toxe=9.286857564e-10
altermod pmos ndep=5.410777350e+18
altermod pmos u0=6.266677308e-03
altermod pmos xj=5.356934595e-09
alter m1 w=2.518728871e-08
alter vd dc=6.472022416e-01
alter vg dc=1.091415941e+00
alter vs dc=1.091308004e+00
alter vb dc=1.091415941e+00
option temp=-3.787328
op
let idx = 260
wrdata C:/Users/udhav/DVD-Project/work/pmos_off_0.out idx i(Vd) i(Vg) i(Vs) i(Vb) @m1[id] @m1[igs] @m1[igd] @m1[igcs] @m1[igcd] @m1[igb] @m1[igidl] @m1[igisl] @m1[isub] @m1[ibd] @m1[ibs]
destroy all
altermod pmos vth0=-3.919017167e-01
altermod pmos toxe=9.030838470e-10
altermod pmos ndep=4.986754742e+18
altermod pmos u0=6.021560948e-03
altermod pmos xj=5.248397270e-09
alter m1 w=9.680243645e-08
alter vd dc=9.184178734e-01
alter vg dc=9.184178734e-01
alter vs dc=9.184178734e-01
alter vb dc=9.184178734e-01
option temp=-14.842907
op
let idx = 261
wrdata C:/Users/udhav/DVD-Project/work/pmos_off_0.out idx i(Vd) i(Vg) i(Vs) i(Vb) @m1[id] @m1[igs] @m1[igd] @m1[igcs] @m1[igcd] @m1[igb] @m1[igidl] @m1[igisl] @m1[isub] @m1[ibd] @m1[ibs]
destroy all
altermod pmos vth0=-4.676113983e-01
altermod pmos toxe=9.063459163e-10
altermod pmos ndep=5.784269687e+18
altermod pmos u0=6.277345369e-03
altermod pmos xj=5.080883427e-09
alter m1 w=9.253071599e-08
alter vd dc=9.492500166e-01
alter vg dc=9.492505533e-01
alter vs dc=3.649904603e-02
alter vb dc=9.492505533e-01
option temp=62.159488
op
let idx = 262
wrdata C:/Users/udhav/DVD-Project/work/pmos_off_0.out idx i(Vd) i(Vg) i(Vs) i(Vb) @m1[id] @m1[igs] @m1[igd] @m1[igcs] @m1[igcd] @m1[igb] @m1[igidl] @m1[igisl] @m1[isub] @m1[ibd] @m1[ibs]
destroy all
altermod pmos vth0=-4.238476662e-01
altermod pmos toxe=9.556347327e-10
altermod pmos ndep=5.929217689e+18
altermod pmos u0=5.463186576e-03
altermod pmos xj=5.241767112e-09
alter m1 w=8.056152172e-08
alter vd dc=5.422916002e-01
alter vg dc=9.530192966e-01
alter vs dc=1.136256682e-01
alter vb dc=9.530192966e-01
option temp=60.955071
op
let idx = 263
wrdata C:/Users/udhav/DVD-Project/work/pmos_off_0.out idx i(Vd) i(Vg) i(Vs) i(Vb) @m1[id] @m1[igs] @m1[igd] @m1[igcs] @m1[igcd] @m1[igb] @m1[igidl] @m1[igisl] @m1[isub] @m1[ibd] @m1[ibs]
destroy all
altermod pmos vth0=-4.313742328e-01
altermod pmos toxe=9.555164832e-10
altermod pmos ndep=6.017767810e+18
altermod pmos u0=6.313904026e-03
altermod pmos xj=4.974590997e-09
alter m1 w=1.112940741e-07
alter vd dc=6.936725561e-01
alter vg dc=9.020683337e-01
alter vs dc=0.000000000e+00
alter vb dc=9.020683337e-01
option temp=19.599384
op
let idx = 264
wrdata C:/Users/udhav/DVD-Project/work/pmos_off_0.out idx i(Vd) i(Vg) i(Vs) i(Vb) @m1[id] @m1[igs] @m1[igd] @m1[igcs] @m1[igcd] @m1[igb] @m1[igidl] @m1[igisl] @m1[isub] @m1[ibd] @m1[ibs]
destroy all
altermod pmos vth0=-4.138330787e-01
altermod pmos toxe=1.024374773e-09
altermod pmos ndep=5.362563265e+18
altermod pmos u0=5.522881644e-03
altermod pmos xj=5.031570667e-09
alter m1 w=9.178509758e-08
alter vd dc=2.637340462e-02
alter vg dc=9.570660062e-01
alter vs dc=9.570660062e-01
alter vb dc=9.570660062e-01
option temp=15.413219
op
let idx = 265
wrdata C:/Users/udhav/DVD-Project/work/pmos_off_0.out idx i(Vd) i(Vg) i(Vs) i(Vb) @m1[id] @m1[igs] @m1[igd] @m1[igcs] @m1[igcd] @m1[igb] @m1[igidl] @m1[igisl] @m1[isub] @m1[ibd] @m1[ibs]
destroy all
altermod pmos vth0=-4.279073341e-01
altermod pmos toxe=1.056369018e-09
altermod pmos ndep=5.460929828e+18
altermod pmos u0=5.756927701e-03
altermod pmos xj=5.304739665e-09
alter m1 w=3.539484420e-08
alter vd dc=1.086162426e+00
alter vg dc=1.086162426e+00
alter vs dc=0.000000000e+00
alter vb dc=1.086162426e+00
option temp=117.328904
op
let idx = 266
wrdata C:/Users/udhav/DVD-Project/work/pmos_off_0.out idx i(Vd) i(Vg) i(Vs) i(Vb) @m1[id] @m1[igs] @m1[igd] @m1[igcs] @m1[igcd] @m1[igb] @m1[igidl] @m1[igisl] @m1[isub] @m1[ibd] @m1[ibs]
destroy all
altermod pmos vth0=-4.484482144e-01
altermod pmos toxe=9.134695251e-10
altermod pmos ndep=5.345102686e+18
altermod pmos u0=5.818260804e-03
altermod pmos xj=4.840428746e-09
alter m1 w=1.952616385e-08
alter vd dc=2.179367571e-01
alter vg dc=9.822093108e-01
alter vs dc=9.822093108e-01
alter vb dc=9.822093108e-01
option temp=76.779141
op
let idx = 267
wrdata C:/Users/udhav/DVD-Project/work/pmos_off_0.out idx i(Vd) i(Vg) i(Vs) i(Vb) @m1[id] @m1[igs] @m1[igd] @m1[igcs] @m1[igcd] @m1[igb] @m1[igidl] @m1[igisl] @m1[isub] @m1[ibd] @m1[ibs]
destroy all
altermod pmos vth0=-4.121010702e-01
altermod pmos toxe=1.097739062e-09
altermod pmos ndep=5.267293866e+18
altermod pmos u0=6.081354910e-03
altermod pmos xj=5.448319730e-09
alter m1 w=7.340251764e-08
alter vd dc=1.070473837e+00
alter vg dc=1.070473837e+00
alter vs dc=6.603900394e-02
alter vb dc=1.070473837e+00
option temp=32.916456
op
let idx = 268
wrdata C:/Users/udhav/DVD-Project/work/pmos_off_0.out idx i(Vd) i(Vg) i(Vs) i(Vb) @m1[id] @m1[igs] @m1[igd] @m1[igcs] @m1[igcd] @m1[igb] @m1[igidl] @m1[igisl] @m1[isub] @m1[ibd] @m1[ibs]
destroy all
altermod pmos vth0=-4.339253258e-01
altermod pmos toxe=9.465484492e-10
altermod pmos ndep=5.349119986e+18
altermod pmos u0=6.288484031e-03
altermod pmos xj=4.748490905e-09
alter m1 w=5.365973406e-08
alter vd dc=6.612933885e-01
alter vg dc=9.028147538e-01
alter vs dc=6.952770860e-01
alter vb dc=9.685427880e-01
option temp=48.330822
op
let idx = 269
wrdata C:/Users/udhav/DVD-Project/work/pmos_off_0.out idx i(Vd) i(Vg) i(Vs) i(Vb) @m1[id] @m1[igs] @m1[igd] @m1[igcs] @m1[igcd] @m1[igb] @m1[igidl] @m1[igisl] @m1[isub] @m1[ibd] @m1[ibs]
destroy all
altermod pmos vth0=-4.674370569e-01
altermod pmos toxe=1.054376326e-09
altermod pmos ndep=5.470605324e+18
altermod pmos u0=5.650421324e-03
altermod pmos xj=4.636556733e-09
alter m1 w=3.202764323e-08
alter vd dc=9.910157151e-01
alter vg dc=1.011517416e+00
alter vs dc=3.445543382e-01
alter vb dc=1.011517416e+00
option temp=55.661302
op
let idx = 270
wrdata C:/Users/udhav/DVD-Project/work/pmos_off_0.out idx i(Vd) i(Vg) i(Vs) i(Vb) @m1[id] @m1[igs] @m1[igd] @m1[igcs] @m1[igcd] @m1[igb] @m1[igidl] @m1[igisl] @m1[isub] @m1[ibd] @m1[ibs]
destroy all
altermod pmos vth0=-4.558323026e-01
altermod pmos toxe=1.052770222e-09
altermod pmos ndep=5.230134806e+18
altermod pmos u0=5.879589550e-03
altermod pmos xj=5.253852562e-09
alter m1 w=5.360208375e-08
alter vd dc=6.795694319e-01
alter vg dc=1.001809283e+00
alter vs dc=0.000000000e+00
alter vb dc=1.063150678e+00
option temp=121.052449
op
let idx = 271
wrdata C:/Users/udhav/DVD-Project/work/pmos_off_0.out idx i(Vd) i(Vg) i(Vs) i(Vb) @m1[id] @m1[igs] @m1[igd] @m1[igcs] @m1[igcd] @m1[igb] @m1[igidl] @m1[igisl] @m1[isub] @m1[ibd] @m1[ibs]
destroy all
altermod pmos vth0=-4.541786412e-01
altermod pmos toxe=9.804763342e-10
altermod pmos ndep=5.034873722e+18
altermod pmos u0=6.293447396e-03
altermod pmos xj=4.963481593e-09
alter m1 w=1.000173772e-07
alter vd dc=4.879882076e-01
alter vg dc=1.092291281e+00
alter vs dc=6.594386436e-01
alter vb dc=1.092291281e+00
option temp=63.328953
op
let idx = 272
wrdata C:/Users/udhav/DVD-Project/work/pmos_off_0.out idx i(Vd) i(Vg) i(Vs) i(Vb) @m1[id] @m1[igs] @m1[igd] @m1[igcs] @m1[igcd] @m1[igb] @m1[igidl] @m1[igisl] @m1[isub] @m1[ibd] @m1[ibs]
destroy all
altermod pmos vth0=-4.119976878e-01
altermod pmos toxe=1.011716133e-09
altermod pmos ndep=5.827477515e+18
altermod pmos u0=5.854600166e-03
altermod pmos xj=4.687426497e-09
alter m1 w=1.061823420e-07
alter vd dc=7.198102278e-01
alter vg dc=9.117805421e-01
alter vs dc=3.497995142e-01
alter vb dc=9.981364455e-01
option temp=-36.113509
op
let idx = 273
wrdata C:/Users/udhav/DVD-Project/work/pmos_off_0.out idx i(Vd) i(Vg) i(Vs) i(Vb) @m1[id] @m1[igs] @m1[igd] @m1[igcs] @m1[igcd] @m1[igb] @m1[igidl] @m1[igisl] @m1[isub] @m1[ibd] @m1[ibs]
destroy all
altermod pmos vth0=-4.570581153e-01
altermod pmos toxe=1.064295640e-09
altermod pmos ndep=5.239673493e+18
altermod pmos u0=6.093819410e-03
altermod pmos xj=4.839798427e-09
alter m1 w=4.754454132e-08
alter vd dc=0.000000000e+00
alter vg dc=9.419274158e-01
alter vs dc=1.427201683e-01
alter vb dc=9.419274158e-01
option temp=-33.862009
op
let idx = 274
wrdata C:/Users/udhav/DVD-Project/work/pmos_off_0.out idx i(Vd) i(Vg) i(Vs) i(Vb) @m1[id] @m1[igs] @m1[igd] @m1[igcs] @m1[igcd] @m1[igb] @m1[igidl] @m1[igisl] @m1[isub] @m1[ibd] @m1[ibs]
destroy all
altermod pmos vth0=-3.931405166e-01
altermod pmos toxe=9.159498965e-10
altermod pmos ndep=5.412175660e+18
altermod pmos u0=6.256550998e-03
altermod pmos xj=4.617814911e-09
alter m1 w=5.222284880e-08
alter vd dc=5.819709629e-01
alter vg dc=9.980383937e-01
alter vs dc=1.019928397e+00
alter vb dc=1.019928397e+00
option temp=124.490403
op
let idx = 275
wrdata C:/Users/udhav/DVD-Project/work/pmos_off_0.out idx i(Vd) i(Vg) i(Vs) i(Vb) @m1[id] @m1[igs] @m1[igd] @m1[igcs] @m1[igcd] @m1[igb] @m1[igidl] @m1[igisl] @m1[isub] @m1[ibd] @m1[ibs]
destroy all
altermod pmos vth0=-4.477575389e-01
altermod pmos toxe=1.056861769e-09
altermod pmos ndep=5.421434999e+18
altermod pmos u0=5.930845386e-03
altermod pmos xj=4.851294205e-09
alter m1 w=1.209453262e-07
alter vd dc=1.127882108e-01
alter vg dc=9.635466435e-01
alter vs dc=2.815904849e-02
alter vb dc=9.635466435e-01
option temp=76.660858
op
let idx = 276
wrdata C:/Users/udhav/DVD-Project/work/pmos_off_0.out idx i(Vd) i(Vg) i(Vs) i(Vb) @m1[id] @m1[igs] @m1[igd] @m1[igcs] @m1[igcd] @m1[igb] @m1[igidl] @m1[igisl] @m1[isub] @m1[ibd] @m1[ibs]
destroy all
altermod pmos vth0=-4.460517159e-01
altermod pmos toxe=9.780742104e-10
altermod pmos ndep=5.044581998e+18
altermod pmos u0=5.446372090e-03
altermod pmos xj=5.166656514e-09
alter m1 w=4.174950400e-08
alter vd dc=0.000000000e+00
alter vg dc=9.625605018e-01
alter vs dc=6.978471152e-01
alter vb dc=9.766534815e-01
option temp=56.797018
op
let idx = 277
wrdata C:/Users/udhav/DVD-Project/work/pmos_off_0.out idx i(Vd) i(Vg) i(Vs) i(Vb) @m1[id] @m1[igs] @m1[igd] @m1[igcs] @m1[igcd] @m1[igb] @m1[igidl] @m1[igisl] @m1[isub] @m1[ibd] @m1[ibs]
destroy all
altermod pmos vth0=-4.588313571e-01
altermod pmos toxe=9.425668878e-10
altermod pmos ndep=5.258767618e+18
altermod pmos u0=5.419656750e-03
altermod pmos xj=4.739102376e-09
alter m1 w=7.856382725e-08
alter vd dc=9.689780523e-01
alter vg dc=9.566965073e-01
alter vs dc=2.463303129e-05
alter vb dc=9.689780523e-01
option temp=87.047062
op
let idx = 278
wrdata C:/Users/udhav/DVD-Project/work/pmos_off_0.out idx i(Vd) i(Vg) i(Vs) i(Vb) @m1[id] @m1[igs] @m1[igd] @m1[igcs] @m1[igcd] @m1[igb] @m1[igidl] @m1[igisl] @m1[isub] @m1[ibd] @m1[ibs]
destroy all
altermod pmos vth0=-4.229613766e-01
altermod pmos toxe=9.162888818e-10
altermod pmos ndep=5.285848912e+18
altermod pmos u0=5.931246892e-03
altermod pmos xj=4.716514594e-09
alter m1 w=2.909015128e-08
alter vd dc=4.778620457e-01
alter vg dc=9.548675452e-01
alter vs dc=8.020702014e-01
alter vb dc=9.548675452e-01
option temp=113.102925
op
let idx = 279
wrdata C:/Users/udhav/DVD-Project/work/pmos_off_0.out idx i(Vd) i(Vg) i(Vs) i(Vb) @m1[id] @m1[igs] @m1[igd] @m1[igcs] @m1[igcd] @m1[igb] @m1[igidl] @m1[igisl] @m1[isub] @m1[ibd] @m1[ibs]
destroy all
altermod pmos vth0=-4.673753066e-01
altermod pmos toxe=9.209945092e-10
altermod pmos ndep=5.446482893e+18
altermod pmos u0=5.525786598e-03
altermod pmos xj=5.153993972e-09
alter m1 w=6.459581933e-08
alter vd dc=0.000000000e+00
alter vg dc=1.013131888e+00
alter vs dc=0.000000000e+00
alter vb dc=1.055708676e+00
option temp=25.255328
op
let idx = 280
wrdata C:/Users/udhav/DVD-Project/work/pmos_off_0.out idx i(Vd) i(Vg) i(Vs) i(Vb) @m1[id] @m1[igs] @m1[igd] @m1[igcs] @m1[igcd] @m1[igb] @m1[igidl] @m1[igisl] @m1[isub] @m1[ibd] @m1[ibs]
destroy all
altermod pmos vth0=-4.460093991e-01
altermod pmos toxe=1.012026118e-09
altermod pmos ndep=5.844896541e+18
altermod pmos u0=5.857561751e-03
altermod pmos xj=5.304792482e-09
alter m1 w=8.436678605e-08
alter vd dc=6.900735541e-01
alter vg dc=9.370032163e-01
alter vs dc=0.000000000e+00
alter vb dc=9.949551042e-01
option temp=-39.987438
op
let idx = 281
wrdata C:/Users/udhav/DVD-Project/work/pmos_off_0.out idx i(Vd) i(Vg) i(Vs) i(Vb) @m1[id] @m1[igs] @m1[igd] @m1[igcs] @m1[igcd] @m1[igb] @m1[igidl] @m1[igisl] @m1[isub] @m1[ibd] @m1[ibs]
destroy all
altermod pmos vth0=-3.972921314e-01
altermod pmos toxe=9.281773071e-10
altermod pmos ndep=5.442010659e+18
altermod pmos u0=6.264989261e-03
altermod pmos xj=5.009069298e-09
alter m1 w=2.899844721e-08
alter vd dc=1.038618790e+00
alter vg dc=1.098695226e+00
alter vs dc=1.042999413e+00
alter vb dc=1.098695226e+00
option temp=48.176853
op
let idx = 282
wrdata C:/Users/udhav/DVD-Project/work/pmos_off_0.out idx i(Vd) i(Vg) i(Vs) i(Vb) @m1[id] @m1[igs] @m1[igd] @m1[igcs] @m1[igcd] @m1[igb] @m1[igidl] @m1[igisl] @m1[isub] @m1[ibd] @m1[ibs]
destroy all
altermod pmos vth0=-4.286384353e-01
altermod pmos toxe=9.680023113e-10
altermod pmos ndep=5.710130236e+18
altermod pmos u0=6.281644707e-03
altermod pmos xj=4.830677072e-09
alter m1 w=9.071176925e-08
alter vd dc=1.091131389e+00
alter vg dc=1.091131389e+00
alter vs dc=1.089032357e+00
alter vb dc=1.091131389e+00
option temp=-30.298674
op
let idx = 283
wrdata C:/Users/udhav/DVD-Project/work/pmos_off_0.out idx i(Vd) i(Vg) i(Vs) i(Vb) @m1[id] @m1[igs] @m1[igd] @m1[igcs] @m1[igcd] @m1[igb] @m1[igidl] @m1[igisl] @m1[isub] @m1[ibd] @m1[ibs]
destroy all
altermod pmos vth0=-4.394559632e-01
altermod pmos toxe=9.115340613e-10
altermod pmos ndep=5.781940163e+18
altermod pmos u0=6.317350494e-03
altermod pmos xj=5.175830259e-09
alter m1 w=1.006421721e-07
alter vd dc=1.093154405e-01
alter vg dc=9.399922212e-01
alter vs dc=0.000000000e+00
alter vb dc=9.399922212e-01
option temp=44.257799
op
let idx = 284
wrdata C:/Users/udhav/DVD-Project/work/pmos_off_0.out idx i(Vd) i(Vg) i(Vs) i(Vb) @m1[id] @m1[igs] @m1[igd] @m1[igcs] @m1[igcd] @m1[igb] @m1[igidl] @m1[igisl] @m1[isub] @m1[ibd] @m1[ibs]
destroy all
altermod pmos vth0=-3.882119356e-01
altermod pmos toxe=1.073942291e-09
altermod pmos ndep=5.006618058e+18
altermod pmos u0=5.681539680e-03
altermod pmos xj=5.461969541e-09
alter m1 w=5.071137831e-08
alter vd dc=8.266827193e-01
alter vg dc=1.060615756e+00
alter vs dc=9.324746456e-01
alter vb dc=1.060615756e+00
option temp=41.048966
op
let idx = 285
wrdata C:/Users/udhav/DVD-Project/work/pmos_off_0.out idx i(Vd) i(Vg) i(Vs) i(Vb) @m1[id] @m1[igs] @m1[igd] @m1[igcs] @m1[igcd] @m1[igb] @m1[igidl] @m1[igisl] @m1[isub] @m1[ibd] @m1[ibs]
destroy all
altermod pmos vth0=-4.571542835e-01
altermod pmos toxe=1.037891747e-09
altermod pmos ndep=5.935233339e+18
altermod pmos u0=6.076162081e-03
altermod pmos xj=4.772758494e-09
alter m1 w=3.520840683e-08
alter vd dc=4.779101149e-01
alter vg dc=1.085411967e+00
alter vs dc=3.653572387e-01
alter vb dc=1.085411967e+00
option temp=119.628311
op
let idx = 286
wrdata C:/Users/udhav/DVD-Project/work/pmos_off_0.out idx i(Vd) i(Vg) i(Vs) i(Vb) @m1[id] @m1[igs] @m1[igd] @m1[igcs] @m1[igcd] @m1[igb] @m1[igidl] @m1[igisl] @m1[isub] @m1[ibd] @m1[ibs]
destroy all
altermod pmos vth0=-3.925111062e-01
altermod pmos toxe=9.624442114e-10
altermod pmos ndep=5.095278199e+18
altermod pmos u0=6.279655131e-03
altermod pmos xj=5.417450151e-09
alter m1 w=7.409492764e-08
alter vd dc=8.785353993e-01
alter vg dc=1.084308860e+00
alter vs dc=0.000000000e+00
alter vb dc=1.084308860e+00
option temp=9.513502
op
let idx = 287
wrdata C:/Users/udhav/DVD-Project/work/pmos_off_0.out idx i(Vd) i(Vg) i(Vs) i(Vb) @m1[id] @m1[igs] @m1[igd] @m1[igcs] @m1[igcd] @m1[igb] @m1[igidl] @m1[igisl] @m1[isub] @m1[ibd] @m1[ibs]
destroy all
altermod pmos vth0=-4.135125123e-01
altermod pmos toxe=1.001415723e-09
altermod pmos ndep=5.672949831e+18
altermod pmos u0=5.866223531e-03
altermod pmos xj=4.686916713e-09
alter m1 w=9.707307519e-08
alter vd dc=1.032001359e+00
alter vg dc=1.032001359e+00
alter vs dc=4.007324294e-01
alter vb dc=1.032001359e+00
option temp=56.457714
op
let idx = 288
wrdata C:/Users/udhav/DVD-Project/work/pmos_off_0.out idx i(Vd) i(Vg) i(Vs) i(Vb) @m1[id] @m1[igs] @m1[igd] @m1[igcs] @m1[igcd] @m1[igb] @m1[igidl] @m1[igisl] @m1[isub] @m1[ibd] @m1[ibs]
destroy all
altermod pmos vth0=-4.408695907e-01
altermod pmos toxe=1.050883541e-09
altermod pmos ndep=5.217451707e+18
altermod pmos u0=5.631357042e-03
altermod pmos xj=5.032984585e-09
alter m1 w=3.212493303e-08
alter vd dc=8.299216957e-01
alter vg dc=9.598503689e-01
alter vs dc=0.000000000e+00
alter vb dc=1.004548550e+00
option temp=71.821847
op
let idx = 289
wrdata C:/Users/udhav/DVD-Project/work/pmos_off_0.out idx i(Vd) i(Vg) i(Vs) i(Vb) @m1[id] @m1[igs] @m1[igd] @m1[igcs] @m1[igcd] @m1[igb] @m1[igidl] @m1[igisl] @m1[isub] @m1[ibd] @m1[ibs]
destroy all
altermod pmos vth0=-4.132854164e-01
altermod pmos toxe=9.721146740e-10
altermod pmos ndep=5.447210943e+18
altermod pmos u0=5.526839262e-03
altermod pmos xj=4.961911385e-09
alter m1 w=8.945394737e-08
alter vd dc=1.085922343e+00
alter vg dc=1.087785327e+00
alter vs dc=1.087785327e+00
alter vb dc=1.087785327e+00
option temp=116.472540
op
let idx = 290
wrdata C:/Users/udhav/DVD-Project/work/pmos_off_0.out idx i(Vd) i(Vg) i(Vs) i(Vb) @m1[id] @m1[igs] @m1[igd] @m1[igcs] @m1[igcd] @m1[igb] @m1[igidl] @m1[igisl] @m1[isub] @m1[ibd] @m1[ibs]
destroy all
altermod pmos vth0=-3.906369106e-01
altermod pmos toxe=1.087259096e-09
altermod pmos ndep=5.444780151e+18
altermod pmos u0=5.680734672e-03
altermod pmos xj=4.893205703e-09
alter m1 w=8.589176682e-08
alter vd dc=0.000000000e+00
alter vg dc=9.207322854e-01
alter vs dc=5.436638561e-02
alter vb dc=9.513159523e-01
option temp=-9.631676
op
let idx = 291
wrdata C:/Users/udhav/DVD-Project/work/pmos_off_0.out idx i(Vd) i(Vg) i(Vs) i(Vb) @m1[id] @m1[igs] @m1[igd] @m1[igcs] @m1[igcd] @m1[igb] @m1[igidl] @m1[igisl] @m1[isub] @m1[ibd] @m1[ibs]
destroy all
altermod pmos vth0=-4.722475308e-01
altermod pmos toxe=1.025321175e-09
altermod pmos ndep=5.042295764e+18
altermod pmos u0=5.838716475e-03
altermod pmos xj=5.093192798e-09
alter m1 w=6.934332929e-08
alter vd dc=0.000000000e+00
alter vg dc=1.086727691e+00
alter vs dc=0.000000000e+00
alter vb dc=1.086727691e+00
option temp=-33.224468
op
let idx = 292
wrdata C:/Users/udhav/DVD-Project/work/pmos_off_0.out idx i(Vd) i(Vg) i(Vs) i(Vb) @m1[id] @m1[igs] @m1[igd] @m1[igcs] @m1[igcd] @m1[igb] @m1[igidl] @m1[igisl] @m1[isub] @m1[ibd] @m1[ibs]
destroy all
altermod pmos vth0=-4.089495482e-01
altermod pmos toxe=1.013172158e-09
altermod pmos ndep=5.248706369e+18
altermod pmos u0=6.210766872e-03
altermod pmos xj=5.449916199e-09
alter m1 w=7.108534966e-08
alter vd dc=8.316216629e-01
alter vg dc=9.183712982e-01
alter vs dc=4.390005642e-02
alter vb dc=9.183712982e-01
option temp=61.163768
op
let idx = 293
wrdata C:/Users/udhav/DVD-Project/work/pmos_off_0.out idx i(Vd) i(Vg) i(Vs) i(Vb) @m1[id] @m1[igs] @m1[igd] @m1[igcs] @m1[igcd] @m1[igb] @m1[igidl] @m1[igisl] @m1[isub] @m1[ibd] @m1[ibs]
destroy all
altermod pmos vth0=-3.888665395e-01
altermod pmos toxe=1.079295161e-09
altermod pmos ndep=5.333000551e+18
altermod pmos u0=5.578602295e-03
altermod pmos xj=4.627970030e-09
alter m1 w=7.386644935e-08
alter vd dc=4.770582426e-03
alter vg dc=9.771199223e-01
alter vs dc=0.000000000e+00
alter vb dc=9.771199223e-01
option temp=82.742187
op
let idx = 294
wrdata C:/Users/udhav/DVD-Project/work/pmos_off_0.out idx i(Vd) i(Vg) i(Vs) i(Vb) @m1[id] @m1[igs] @m1[igd] @m1[igcs] @m1[igcd] @m1[igb] @m1[igidl] @m1[igisl] @m1[isub] @m1[ibd] @m1[ibs]
destroy all
altermod pmos vth0=-4.470089017e-01
altermod pmos toxe=1.001720758e-09
altermod pmos ndep=5.485260904e+18
altermod pmos u0=5.811539207e-03
altermod pmos xj=4.514824390e-09
alter m1 w=1.260407178e-07
alter vd dc=1.312416391e-02
alter vg dc=1.027663951e+00
alter vs dc=1.027663951e+00
alter vb dc=1.027663951e+00
option temp=51.461251
op
let idx = 295
wrdata C:/Users/udhav/DVD-Project/work/pmos_off_0.out idx i(Vd) i(Vg) i(Vs) i(Vb) @m1[id] @m1[igs] @m1[igd] @m1[igcs] @m1[igcd] @m1[igb] @m1[igidl] @m1[igisl] @m1[isub] @m1[ibd] @m1[ibs]
destroy all
altermod pmos vth0=-4.374588691e-01
altermod pmos toxe=1.090429019e-09
altermod pmos ndep=6.024258817e+18
altermod pmos u0=6.166456595e-03
altermod pmos xj=5.391542035e-09
alter m1 w=8.511183200e-08
alter vd dc=1.179259816e-01
alter vg dc=1.036115589e+00
alter vs dc=0.000000000e+00
alter vb dc=1.036115589e+00
option temp=26.961308
op
let idx = 296
wrdata C:/Users/udhav/DVD-Project/work/pmos_off_0.out idx i(Vd) i(Vg) i(Vs) i(Vb) @m1[id] @m1[igs] @m1[igd] @m1[igcs] @m1[igcd] @m1[igb] @m1[igidl] @m1[igisl] @m1[isub] @m1[ibd] @m1[ibs]
destroy all
altermod pmos vth0=-4.352677308e-01
altermod pmos toxe=1.011294071e-09
altermod pmos ndep=5.231735888e+18
altermod pmos u0=5.825531888e-03
altermod pmos xj=5.191977705e-09
alter m1 w=1.112071680e-07
alter vd dc=5.887663984e-01
alter vg dc=9.611972020e-01
alter vs dc=8.465023773e-01
alter vb dc=9.611972020e-01
option temp=89.929225
op
let idx = 297
wrdata C:/Users/udhav/DVD-Project/work/pmos_off_0.out idx i(Vd) i(Vg) i(Vs) i(Vb) @m1[id] @m1[igs] @m1[igd] @m1[igcs] @m1[igcd] @m1[igb] @m1[igidl] @m1[igisl] @m1[isub] @m1[ibd] @m1[ibs]
destroy all
altermod pmos vth0=-4.721973776e-01
altermod pmos toxe=1.044970237e-09
altermod pmos ndep=5.809550384e+18
altermod pmos u0=6.543608488e-03
altermod pmos xj=4.786697273e-09
alter m1 w=1.262941843e-07
alter vd dc=5.002444866e-01
alter vg dc=1.001434956e+00
alter vs dc=0.000000000e+00
alter vb dc=1.059793832e+00
option temp=67.483433
op
let idx = 298
wrdata C:/Users/udhav/DVD-Project/work/pmos_off_0.out idx i(Vd) i(Vg) i(Vs) i(Vb) @m1[id] @m1[igs] @m1[igd] @m1[igcs] @m1[igcd] @m1[igb] @m1[igidl] @m1[igisl] @m1[isub] @m1[ibd] @m1[ibs]
destroy all
altermod pmos vth0=-4.249585959e-01
altermod pmos toxe=1.047115006e-09
altermod pmos ndep=5.899636599e+18
altermod pmos u0=6.561222499e-03
altermod pmos xj=5.305515493e-09
alter m1 w=2.076858065e-08
alter vd dc=6.318283665e-01
alter vg dc=1.033021477e+00
alter vs dc=7.949992450e-01
alter vb dc=1.094398646e+00
option temp=-38.549574
op
let idx = 299
wrdata C:/Users/udhav/DVD-Project/work/pmos_off_0.out idx i(Vd) i(Vg) i(Vs) i(Vb) @m1[id] @m1[igs] @m1[igd] @m1[igcs] @m1[igcd] @m1[igb] @m1[igidl] @m1[igisl] @m1[isub] @m1[ibd] @m1[ibs]
destroy all
altermod pmos vth0=-4.216125575e-01
altermod pmos toxe=9.012669017e-10
altermod pmos ndep=4.977483830e+18
altermod pmos u0=5.891973583e-03
altermod pmos xj=4.818285798e-09
alter m1 w=5.353627981e-08
alter vd dc=2.314393159e-01
alter vg dc=9.960315523e-01
alter vs dc=0.000000000e+00
alter vb dc=1.004624888e+00
option temp=116.660955
op
let idx = 300
wrdata C:/Users/udhav/DVD-Project/work/pmos_off_0.out idx i(Vd) i(Vg) i(Vs) i(Vb) @m1[id] @m1[igs] @m1[igd] @m1[igcs] @m1[igcd] @m1[igb] @m1[igidl] @m1[igisl] @m1[isub] @m1[ibd] @m1[ibs]
destroy all
altermod pmos vth0=-4.265473828e-01
altermod pmos toxe=1.079743879e-09
altermod pmos ndep=5.526415124e+18
altermod pmos u0=6.102166843e-03
altermod pmos xj=4.547229098e-09
alter m1 w=1.133958113e-07
alter vd dc=9.869232002e-01
alter vg dc=9.347333309e-01
alter vs dc=9.869232002e-01
alter vb dc=9.869232002e-01
option temp=37.730336
op
let idx = 301
wrdata C:/Users/udhav/DVD-Project/work/pmos_off_0.out idx i(Vd) i(Vg) i(Vs) i(Vb) @m1[id] @m1[igs] @m1[igd] @m1[igcs] @m1[igcd] @m1[igb] @m1[igidl] @m1[igisl] @m1[isub] @m1[ibd] @m1[ibs]
destroy all
altermod pmos vth0=-3.989718405e-01
altermod pmos toxe=1.030283251e-09
altermod pmos ndep=5.154348451e+18
altermod pmos u0=6.133897625e-03
altermod pmos xj=5.253692116e-09
alter m1 w=1.608812136e-08
alter vd dc=9.367564623e-01
alter vg dc=9.367564623e-01
alter vs dc=0.000000000e+00
alter vb dc=9.367564623e-01
option temp=-6.766750
op
let idx = 302
wrdata C:/Users/udhav/DVD-Project/work/pmos_off_0.out idx i(Vd) i(Vg) i(Vs) i(Vb) @m1[id] @m1[igs] @m1[igd] @m1[igcs] @m1[igcd] @m1[igb] @m1[igidl] @m1[igisl] @m1[isub] @m1[ibd] @m1[ibs]
destroy all
altermod pmos vth0=-4.400647473e-01
altermod pmos toxe=9.086744698e-10
altermod pmos ndep=4.951056253e+18
altermod pmos u0=6.483776133e-03
altermod pmos xj=5.126347497e-09
alter m1 w=5.615207858e-08
alter vd dc=5.406730692e-01
alter vg dc=9.176375696e-01
alter vs dc=9.176375696e-01
alter vb dc=9.176375696e-01
option temp=-25.024581
op
let idx = 303
wrdata C:/Users/udhav/DVD-Project/work/pmos_off_0.out idx i(Vd) i(Vg) i(Vs) i(Vb) @m1[id] @m1[igs] @m1[igd] @m1[igcs] @m1[igcd] @m1[igb] @m1[igidl] @m1[igisl] @m1[isub] @m1[ibd] @m1[ibs]
destroy all
altermod pmos vth0=-4.554244026e-01
altermod pmos toxe=9.437940628e-10
altermod pmos ndep=5.139329172e+18
altermod pmos u0=6.139647924e-03
altermod pmos xj=5.037144175e-09
alter m1 w=2.867200274e-08
alter vd dc=9.685793186e-01
alter vg dc=8.778413288e-01
alter vs dc=4.741399188e-01
alter vb dc=9.685793186e-01
option temp=114.860141
op
let idx = 304
wrdata C:/Users/udhav/DVD-Project/work/pmos_off_0.out idx i(Vd) i(Vg) i(Vs) i(Vb) @m1[id] @m1[igs] @m1[igd] @m1[igcs] @m1[igcd] @m1[igb] @m1[igidl] @m1[igisl] @m1[isub] @m1[ibd] @m1[ibs]
destroy all
altermod pmos vth0=-4.602791312e-01
altermod pmos toxe=1.096989116e-09
altermod pmos ndep=5.102995168e+18
altermod pmos u0=6.476068945e-03
altermod pmos xj=4.694635850e-09
alter m1 w=6.398462632e-08
alter vd dc=4.974761724e-01
alter vg dc=9.951784628e-01
alter vs dc=1.406399262e-01
alter vb dc=1.071593626e+00
option temp=-37.636347
op
let idx = 305
wrdata C:/Users/udhav/DVD-Project/work/pmos_off_0.out idx i(Vd) i(Vg) i(Vs) i(Vb) @m1[id] @m1[igs] @m1[igd] @m1[igcs] @m1[igcd] @m1[igb] @m1[igidl] @m1[igisl] @m1[isub] @m1[ibd] @m1[ibs]
destroy all
altermod pmos vth0=-4.042013323e-01
altermod pmos toxe=9.080104955e-10
altermod pmos ndep=5.898781316e+18
altermod pmos u0=6.510083021e-03
altermod pmos xj=5.131996206e-09
alter m1 w=8.123898088e-08
alter vd dc=1.035026746e+00
alter vg dc=9.677047460e-01
alter vs dc=1.896987915e-01
alter vb dc=1.069728946e+00
option temp=13.617324
op
let idx = 306
wrdata C:/Users/udhav/DVD-Project/work/pmos_off_0.out idx i(Vd) i(Vg) i(Vs) i(Vb) @m1[id] @m1[igs] @m1[igd] @m1[igcs] @m1[igcd] @m1[igb] @m1[igidl] @m1[igisl] @m1[isub] @m1[ibd] @m1[ibs]
destroy all
altermod pmos vth0=-4.679701525e-01
altermod pmos toxe=1.059363535e-09
altermod pmos ndep=5.046220134e+18
altermod pmos u0=6.408017990e-03
altermod pmos xj=5.489503406e-09
alter m1 w=7.789641433e-08
alter vd dc=6.144390751e-01
alter vg dc=9.591249989e-01
alter vs dc=9.591249989e-01
alter vb dc=9.591249989e-01
option temp=97.611170
op
let idx = 307
wrdata C:/Users/udhav/DVD-Project/work/pmos_off_0.out idx i(Vd) i(Vg) i(Vs) i(Vb) @m1[id] @m1[igs] @m1[igd] @m1[igcs] @m1[igcd] @m1[igb] @m1[igidl] @m1[igisl] @m1[isub] @m1[ibd] @m1[ibs]
destroy all
altermod pmos vth0=-4.578772487e-01
altermod pmos toxe=1.018051693e-09
altermod pmos ndep=5.538774766e+18
altermod pmos u0=6.512432287e-03
altermod pmos xj=4.643042530e-09
alter m1 w=1.119241915e-07
alter vd dc=4.290650321e-01
alter vg dc=9.933302885e-01
alter vs dc=6.603939251e-01
alter vb dc=1.060103176e+00
option temp=9.813434
op
let idx = 308
wrdata C:/Users/udhav/DVD-Project/work/pmos_off_0.out idx i(Vd) i(Vg) i(Vs) i(Vb) @m1[id] @m1[igs] @m1[igd] @m1[igcs] @m1[igcd] @m1[igb] @m1[igidl] @m1[igisl] @m1[isub] @m1[ibd] @m1[ibs]
destroy all
altermod pmos vth0=-4.255663680e-01
altermod pmos toxe=1.000904703e-09
altermod pmos ndep=6.031726484e+18
altermod pmos u0=5.807574677e-03
altermod pmos xj=4.873843609e-09
alter m1 w=9.425144197e-08
alter vd dc=8.112898115e-05
alter vg dc=8.729507044e-01
alter vs dc=6.696646724e-01
alter vb dc=9.133817089e-01
option temp=10.823550
op
let idx = 309
wrdata C:/Users/udhav/DVD-Project/work/pmos_off_0.out idx i(Vd) i(Vg) i(Vs) i(Vb) @m1[id] @m1[igs] @m1[igd] @m1[igcs] @m1[igcd] @m1[igb] @m1[igidl] @m1[igisl] @m1[isub] @m1[ibd] @m1[ibs]
destroy all
altermod pmos vth0=-4.701604448e-01
altermod pmos toxe=1.014002239e-09
altermod pmos ndep=5.789488126e+18
altermod pmos u0=6.033319314e-03
altermod pmos xj=5.208050207e-09
alter m1 w=8.734389491e-08
alter vd dc=9.723746454e-02
alter vg dc=9.672952079e-01
alter vs dc=0.000000000e+00
alter vb dc=1.074020122e+00
option temp=115.364732
op
let idx = 310
wrdata C:/Users/udhav/DVD-Project/work/pmos_off_0.out idx i(Vd) i(Vg) i(Vs) i(Vb) @m1[id] @m1[igs] @m1[igd] @m1[igcs] @m1[igcd] @m1[igb] @m1[igidl] @m1[igisl] @m1[isub] @m1[ibd] @m1[ibs]
destroy all
altermod pmos vth0=-4.233967866e-01
altermod pmos toxe=9.332329330e-10
altermod pmos ndep=5.479306984e+18
altermod pmos u0=5.468225228e-03
altermod pmos xj=5.404210721e-09
alter m1 w=7.931480739e-08
alter vd dc=0.000000000e+00
alter vg dc=8.886079952e-01
alter vs dc=9.352152247e-01
alter vb dc=9.352152247e-01
option temp=20.031318
op
let idx = 311
wrdata C:/Users/udhav/DVD-Project/work/pmos_off_0.out idx i(Vd) i(Vg) i(Vs) i(Vb) @m1[id] @m1[igs] @m1[igd] @m1[igcs] @m1[igcd] @m1[igb] @m1[igidl] @m1[igisl] @m1[isub] @m1[ibd] @m1[ibs]
destroy all
altermod pmos vth0=-4.336997463e-01
altermod pmos toxe=1.018620779e-09
altermod pmos ndep=5.381067383e+18
altermod pmos u0=6.409958779e-03
altermod pmos xj=4.631451063e-09
alter m1 w=3.321324486e-08
alter vd dc=1.038037094e+00
alter vg dc=9.375737177e-01
alter vs dc=1.876223900e-01
alter vb dc=1.038037094e+00
option temp=87.600295
op
let idx = 312
wrdata C:/Users/udhav/DVD-Project/work/pmos_off_0.out idx i(Vd) i(Vg) i(Vs) i(Vb) @m1[id] @m1[igs] @m1[igd] @m1[igcs] @m1[igcd] @m1[igb] @m1[igidl] @m1[igisl] @m1[isub] @m1[ibd] @m1[ibs]
destroy all
altermod pmos vth0=-4.541619587e-01
altermod pmos toxe=9.187045589e-10
altermod pmos ndep=5.850726548e+18
altermod pmos u0=6.120134759e-03
altermod pmos xj=4.583053432e-09
alter m1 w=2.769353028e-08
alter vd dc=5.480815969e-02
alter vg dc=8.541241377e-01
alter vs dc=5.832697218e-01
alter vb dc=9.324780941e-01
option temp=49.075321
op
let idx = 313
wrdata C:/Users/udhav/DVD-Project/work/pmos_off_0.out idx i(Vd) i(Vg) i(Vs) i(Vb) @m1[id] @m1[igs] @m1[igd] @m1[igcs] @m1[igcd] @m1[igb] @m1[igidl] @m1[igisl] @m1[isub] @m1[ibd] @m1[ibs]
destroy all
altermod pmos vth0=-4.238196285e-01
altermod pmos toxe=1.085290244e-09
altermod pmos ndep=5.491508862e+18
altermod pmos u0=5.455702382e-03
altermod pmos xj=5.397668135e-09
alter m1 w=6.854531932e-08
alter vd dc=0.000000000e+00
alter vg dc=9.087402887e-01
alter vs dc=1.108410426e-01
alter vb dc=1.003508200e+00
option temp=69.642877
op
let idx = 314
wrdata C:/Users/udhav/DVD-Project/work/pmos_off_0.out idx i(Vd) i(Vg) i(Vs) i(Vb) @m1[id] @m1[igs] @m1[igd] @m1[igcs] @m1[igcd] @m1[igb] @m1[igidl] @m1[igisl] @m1[isub] @m1[ibd] @m1[ibs]
destroy all
altermod pmos vth0=-3.996172613e-01
altermod pmos toxe=9.644186357e-10
altermod pmos ndep=5.228855108e+18
altermod pmos u0=6.384317624e-03
altermod pmos xj=4.917934719e-09
alter m1 w=6.054451498e-08
alter vd dc=9.519678064e-01
alter vg dc=8.806769322e-01
alter vs dc=7.129965077e-01
alter vb dc=9.527089339e-01
option temp=24.799096
op
let idx = 315
wrdata C:/Users/udhav/DVD-Project/work/pmos_off_0.out idx i(Vd) i(Vg) i(Vs) i(Vb) @m1[id] @m1[igs] @m1[igd] @m1[igcs] @m1[igcd] @m1[igb] @m1[igidl] @m1[igisl] @m1[isub] @m1[ibd] @m1[ibs]
destroy all
altermod pmos vth0=-4.621554217e-01
altermod pmos toxe=1.022714995e-09
altermod pmos ndep=5.690792202e+18
altermod pmos u0=5.738174294e-03
altermod pmos xj=5.413038932e-09
alter m1 w=9.113673026e-08
alter vd dc=0.000000000e+00
alter vg dc=9.179070055e-01
alter vs dc=0.000000000e+00
alter vb dc=9.549026922e-01
option temp=77.613878
op
let idx = 316
wrdata C:/Users/udhav/DVD-Project/work/pmos_off_0.out idx i(Vd) i(Vg) i(Vs) i(Vb) @m1[id] @m1[igs] @m1[igd] @m1[igcs] @m1[igcd] @m1[igb] @m1[igidl] @m1[igisl] @m1[isub] @m1[ibd] @m1[ibs]
destroy all
altermod pmos vth0=-4.226155032e-01
altermod pmos toxe=1.051260045e-09
altermod pmos ndep=5.440409874e+18
altermod pmos u0=6.138435802e-03
altermod pmos xj=5.375664938e-09
alter m1 w=1.254494226e-07
alter vd dc=9.204498602e-01
alter vg dc=9.085249573e-01
alter vs dc=9.204498602e-01
alter vb dc=9.204498602e-01
option temp=60.428898
op
let idx = 317
wrdata C:/Users/udhav/DVD-Project/work/pmos_off_0.out idx i(Vd) i(Vg) i(Vs) i(Vb) @m1[id] @m1[igs] @m1[igd] @m1[igcs] @m1[igcd] @m1[igb] @m1[igidl] @m1[igisl] @m1[isub] @m1[ibd] @m1[ibs]
destroy all
altermod pmos vth0=-4.263621444e-01
altermod pmos toxe=1.046198803e-09
altermod pmos ndep=5.791400998e+18
altermod pmos u0=5.911107705e-03
altermod pmos xj=5.264463112e-09
alter m1 w=1.749955699e-08
alter vd dc=3.594476422e-02
alter vg dc=8.278906175e-01
alter vs dc=9.036486631e-01
alter vb dc=9.036486631e-01
option temp=26.254820
op
let idx = 318
wrdata C:/Users/udhav/DVD-Project/work/pmos_off_0.out idx i(Vd) i(Vg) i(Vs) i(Vb) @m1[id] @m1[igs] @m1[igd] @m1[igcs] @m1[igcd] @m1[igb] @m1[igidl] @m1[igisl] @m1[isub] @m1[ibd] @m1[ibs]
destroy all
altermod pmos vth0=-4.398955019e-01
altermod pmos toxe=1.046691059e-09
altermod pmos ndep=5.597455017e+18
altermod pmos u0=6.597235339e-03
altermod pmos xj=5.413440563e-09
alter m1 w=1.117952767e-07
alter vd dc=4.163938751e-04
alter vg dc=9.866138623e-01
alter vs dc=9.684852616e-01
alter vb dc=9.876394278e-01
option temp=113.635537
op
let idx = 319
wrdata C:/Users/udhav/DVD-Project/work/pmos_off_0.out idx i(Vd) i(Vg) i(Vs) i(Vb) @m1[id] @m1[igs] @m1[igd] @m1[igcs] @m1[igcd] @m1[igb] @m1[igidl] @m1[igisl] @m1[isub] @m1[ibd] @m1[ibs]
destroy all
altermod pmos vth0=-4.084112500e-01
altermod pmos toxe=1.081056841e-09
altermod pmos ndep=4.992380784e+18
altermod pmos u0=5.624338315e-03
altermod pmos xj=4.975858153e-09
alter m1 w=1.275437632e-07
alter vd dc=2.227772726e-01
alter vg dc=9.651922233e-01
alter vs dc=9.651922233e-01
alter vb dc=9.651922233e-01
option temp=122.164263
op
let idx = 320
wrdata C:/Users/udhav/DVD-Project/work/pmos_off_0.out idx i(Vd) i(Vg) i(Vs) i(Vb) @m1[id] @m1[igs] @m1[igd] @m1[igcs] @m1[igcd] @m1[igb] @m1[igidl] @m1[igisl] @m1[isub] @m1[ibd] @m1[ibs]
destroy all
altermod pmos vth0=-4.675470533e-01
altermod pmos toxe=9.336704092e-10
altermod pmos ndep=5.993838560e+18
altermod pmos u0=5.671933455e-03
altermod pmos xj=4.796094632e-09
alter m1 w=6.700395484e-08
alter vd dc=3.584146502e-01
alter vg dc=8.949879436e-01
alter vs dc=8.078769246e-01
alter vb dc=9.767294312e-01
option temp=104.147019
op
let idx = 321
wrdata C:/Users/udhav/DVD-Project/work/pmos_off_0.out idx i(Vd) i(Vg) i(Vs) i(Vb) @m1[id] @m1[igs] @m1[igd] @m1[igcs] @m1[igcd] @m1[igb] @m1[igidl] @m1[igisl] @m1[isub] @m1[ibd] @m1[ibs]
destroy all
altermod pmos vth0=-4.231324948e-01
altermod pmos toxe=9.744438953e-10
altermod pmos ndep=5.486479368e+18
altermod pmos u0=5.511749290e-03
altermod pmos xj=4.625804313e-09
alter m1 w=1.242942302e-07
alter vd dc=1.014256926e+00
alter vg dc=9.746289225e-01
alter vs dc=1.466706556e-01
alter vb dc=1.014256926e+00
option temp=66.900325
op
let idx = 322
wrdata C:/Users/udhav/DVD-Project/work/pmos_off_0.out idx i(Vd) i(Vg) i(Vs) i(Vb) @m1[id] @m1[igs] @m1[igd] @m1[igcs] @m1[igcd] @m1[igb] @m1[igidl] @m1[igisl] @m1[isub] @m1[ibd] @m1[ibs]
destroy all
altermod pmos vth0=-4.010803572e-01
altermod pmos toxe=1.029717968e-09
altermod pmos ndep=5.193030619e+18
altermod pmos u0=5.973282893e-03
altermod pmos xj=5.426988220e-09
alter m1 w=1.103621935e-07
alter vd dc=1.578755656e-03
alter vg dc=1.042785945e+00
alter vs dc=0.000000000e+00
alter vb dc=1.056747390e+00
option temp=74.587725
op
let idx = 323
wrdata C:/Users/udhav/DVD-Project/work/pmos_off_0.out idx i(Vd) i(Vg) i(Vs) i(Vb) @m1[id] @m1[igs] @m1[igd] @m1[igcs] @m1[igcd] @m1[igb] @m1[igidl] @m1[igisl] @m1[isub] @m1[ibd] @m1[ibs]
destroy all
altermod pmos vth0=-4.650039138e-01
altermod pmos toxe=1.041567754e-09
altermod pmos ndep=5.936085866e+18
altermod pmos u0=5.880064304e-03
altermod pmos xj=5.203420564e-09
alter m1 w=1.091247220e-07
alter vd dc=9.197340811e-01
alter vg dc=9.137709430e-01
alter vs dc=9.005333521e-01
alter vb dc=9.197340811e-01
option temp=45.887026
op
let idx = 324
wrdata C:/Users/udhav/DVD-Project/work/pmos_off_0.out idx i(Vd) i(Vg) i(Vs) i(Vb) @m1[id] @m1[igs] @m1[igd] @m1[igcs] @m1[igcd] @m1[igb] @m1[igidl] @m1[igisl] @m1[isub] @m1[ibd] @m1[ibs]
destroy all
altermod pmos vth0=-4.708389131e-01
altermod pmos toxe=9.303040414e-10
altermod pmos ndep=5.100182285e+18
altermod pmos u0=5.981092504e-03
altermod pmos xj=4.874702995e-09
alter m1 w=8.681092747e-08
alter vd dc=0.000000000e+00
alter vg dc=1.038595255e+00
alter vs dc=2.338275676e-01
alter vb dc=1.038595255e+00
option temp=-26.453380
op
let idx = 325
wrdata C:/Users/udhav/DVD-Project/work/pmos_off_0.out idx i(Vd) i(Vg) i(Vs) i(Vb) @m1[id] @m1[igs] @m1[igd] @m1[igcs] @m1[igcd] @m1[igb] @m1[igidl] @m1[igisl] @m1[isub] @m1[ibd] @m1[ibs]
destroy all
altermod pmos vth0=-3.943753010e-01
altermod pmos toxe=9.452114895e-10
altermod pmos ndep=5.341445922e+18
altermod pmos u0=5.767851366e-03
altermod pmos xj=4.535778445e-09
alter m1 w=1.996733541e-08
alter vd dc=1.062684967e+00
alter vg dc=1.069075870e+00
alter vs dc=1.069075870e+00
alter vb dc=1.069075870e+00
option temp=-27.520279
op
let idx = 326
wrdata C:/Users/udhav/DVD-Project/work/pmos_off_0.out idx i(Vd) i(Vg) i(Vs) i(Vb) @m1[id] @m1[igs] @m1[igd] @m1[igcs] @m1[igcd] @m1[igb] @m1[igidl] @m1[igisl] @m1[isub] @m1[ibd] @m1[ibs]
destroy all
altermod pmos vth0=-4.471550969e-01
altermod pmos toxe=9.167178872e-10
altermod pmos ndep=5.567753107e+18
altermod pmos u0=5.470494270e-03
altermod pmos xj=5.213751754e-09
alter m1 w=9.355186280e-08
alter vd dc=7.981311266e-01
alter vg dc=9.630801985e-01
alter vs dc=3.824623198e-01
alter vb dc=9.705878175e-01
option temp=105.668545
op
let idx = 327
wrdata C:/Users/udhav/DVD-Project/work/pmos_off_0.out idx i(Vd) i(Vg) i(Vs) i(Vb) @m1[id] @m1[igs] @m1[igd] @m1[igcs] @m1[igcd] @m1[igb] @m1[igidl] @m1[igisl] @m1[isub] @m1[ibd] @m1[ibs]
destroy all
altermod pmos vth0=-4.287695702e-01
altermod pmos toxe=1.042712866e-09
altermod pmos ndep=5.451272567e+18
altermod pmos u0=5.509449527e-03
altermod pmos xj=4.747752811e-09
alter m1 w=1.187062491e-07
alter vd dc=5.139376188e-01
alter vg dc=8.283848453e-01
alter vs dc=9.143200030e-01
alter vb dc=9.143200030e-01
option temp=88.765420
op
let idx = 328
wrdata C:/Users/udhav/DVD-Project/work/pmos_off_0.out idx i(Vd) i(Vg) i(Vs) i(Vb) @m1[id] @m1[igs] @m1[igd] @m1[igcs] @m1[igcd] @m1[igb] @m1[igidl] @m1[igisl] @m1[isub] @m1[ibd] @m1[ibs]
destroy all
altermod pmos vth0=-4.218667835e-01
altermod pmos toxe=9.058389238e-10
altermod pmos ndep=4.978559355e+18
altermod pmos u0=5.504780296e-03
altermod pmos xj=4.629401161e-09
alter m1 w=4.191611732e-08
alter vd dc=0.000000000e+00
alter vg dc=1.029480565e+00
alter vs dc=7.767154950e-01
alter vb dc=1.029480565e+00
option temp=3.297812
op
let idx = 329
wrdata C:/Users/udhav/DVD-Project/work/pmos_off_0.out idx i(Vd) i(Vg) i(Vs) i(Vb) @m1[id] @m1[igs] @m1[igd] @m1[igcs] @m1[igcd] @m1[igb] @m1[igidl] @m1[igisl] @m1[isub] @m1[ibd] @m1[ibs]
destroy all
altermod pmos vth0=-4.596244408e-01
altermod pmos toxe=9.813570831e-10
altermod pmos ndep=4.956960151e+18
altermod pmos u0=6.026227366e-03
altermod pmos xj=5.133703383e-09
alter m1 w=9.039192743e-08
alter vd dc=3.834311330e-01
alter vg dc=9.457420269e-01
alter vs dc=1.233314900e-01
alter vb dc=9.457420269e-01
option temp=48.667780
op
let idx = 330
wrdata C:/Users/udhav/DVD-Project/work/pmos_off_0.out idx i(Vd) i(Vg) i(Vs) i(Vb) @m1[id] @m1[igs] @m1[igd] @m1[igcs] @m1[igcd] @m1[igb] @m1[igidl] @m1[igisl] @m1[isub] @m1[ibd] @m1[ibs]
destroy all
altermod pmos vth0=-4.308503622e-01
altermod pmos toxe=9.939026401e-10
altermod pmos ndep=5.990155881e+18
altermod pmos u0=5.730334074e-03
altermod pmos xj=4.788183708e-09
alter m1 w=4.805680226e-08
alter vd dc=9.321742851e-01
alter vg dc=9.125535547e-01
alter vs dc=9.600353528e-01
alter vb dc=9.600353528e-01
option temp=12.636164
op
let idx = 331
wrdata C:/Users/udhav/DVD-Project/work/pmos_off_0.out idx i(Vd) i(Vg) i(Vs) i(Vb) @m1[id] @m1[igs] @m1[igd] @m1[igcs] @m1[igcd] @m1[igb] @m1[igidl] @m1[igisl] @m1[isub] @m1[ibd] @m1[ibs]
destroy all
altermod pmos vth0=-4.471773925e-01
altermod pmos toxe=9.740498001e-10
altermod pmos ndep=5.577382800e+18
altermod pmos u0=6.095326936e-03
altermod pmos xj=5.130036679e-09
alter m1 w=3.036002735e-08
alter vd dc=2.084463856e-01
alter vg dc=9.493250281e-01
alter vs dc=0.000000000e+00
alter vb dc=9.612532372e-01
option temp=32.831746
op
let idx = 332
wrdata C:/Users/udhav/DVD-Project/work/pmos_off_0.out idx i(Vd) i(Vg) i(Vs) i(Vb) @m1[id] @m1[igs] @m1[igd] @m1[igcs] @m1[igcd] @m1[igb] @m1[igidl] @m1[igisl] @m1[isub] @m1[ibd] @m1[ibs]
destroy all
altermod pmos vth0=-4.287519943e-01
altermod pmos toxe=9.000469855e-10
altermod pmos ndep=6.009898303e+18
altermod pmos u0=6.205338853e-03
altermod pmos xj=5.344214491e-09
alter m1 w=1.706530673e-08
alter vd dc=9.020204898e-01
alter vg dc=9.020204898e-01
alter vs dc=2.079762501e-01
alter vb dc=9.020204898e-01
option temp=-26.268295
op
let idx = 333
wrdata C:/Users/udhav/DVD-Project/work/pmos_off_0.out idx i(Vd) i(Vg) i(Vs) i(Vb) @m1[id] @m1[igs] @m1[igd] @m1[igcs] @m1[igcd] @m1[igb] @m1[igidl] @m1[igisl] @m1[isub] @m1[ibd] @m1[ibs]
destroy all
altermod pmos vth0=-3.959089504e-01
altermod pmos toxe=1.044844644e-09
altermod pmos ndep=5.169488220e+18
altermod pmos u0=5.794280811e-03
altermod pmos xj=4.671264889e-09
alter m1 w=2.500840806e-08
alter vd dc=9.460298153e-01
alter vg dc=1.034698623e+00
alter vs dc=0.000000000e+00
alter vb dc=1.034698623e+00
option temp=-39.320364
op
let idx = 334
wrdata C:/Users/udhav/DVD-Project/work/pmos_off_0.out idx i(Vd) i(Vg) i(Vs) i(Vb) @m1[id] @m1[igs] @m1[igd] @m1[igcs] @m1[igcd] @m1[igb] @m1[igidl] @m1[igisl] @m1[isub] @m1[ibd] @m1[ibs]
destroy all
altermod pmos vth0=-4.352610125e-01
altermod pmos toxe=1.058611181e-09
altermod pmos ndep=5.546316037e+18
altermod pmos u0=6.162953631e-03
altermod pmos xj=5.423448628e-09
alter m1 w=2.607272143e-08
alter vd dc=9.225181152e-01
alter vg dc=1.042226596e+00
alter vs dc=3.934853842e-01
alter vb dc=1.042226596e+00
option temp=35.199649
op
let idx = 335
wrdata C:/Users/udhav/DVD-Project/work/pmos_off_0.out idx i(Vd) i(Vg) i(Vs) i(Vb) @m1[id] @m1[igs] @m1[igd] @m1[igcs] @m1[igcd] @m1[igb] @m1[igidl] @m1[igisl] @m1[isub] @m1[ibd] @m1[ibs]
destroy all
altermod pmos vth0=-4.364414239e-01
altermod pmos toxe=9.867979948e-10
altermod pmos ndep=5.753022076e+18
altermod pmos u0=6.450331280e-03
altermod pmos xj=5.301040379e-09
alter m1 w=3.040074177e-08
alter vd dc=7.965815719e-01
alter vg dc=9.576462118e-01
alter vs dc=4.136840579e-01
alter vb dc=9.576462118e-01
option temp=-23.302361
op
let idx = 336
wrdata C:/Users/udhav/DVD-Project/work/pmos_off_0.out idx i(Vd) i(Vg) i(Vs) i(Vb) @m1[id] @m1[igs] @m1[igd] @m1[igcs] @m1[igcd] @m1[igb] @m1[igidl] @m1[igisl] @m1[isub] @m1[ibd] @m1[ibs]
destroy all
altermod pmos vth0=-4.444539872e-01
altermod pmos toxe=1.025799847e-09
altermod pmos ndep=5.119502559e+18
altermod pmos u0=6.181217201e-03
altermod pmos xj=4.514715907e-09
alter m1 w=4.408016171e-08
alter vd dc=4.351879944e-01
alter vg dc=9.653157276e-01
alter vs dc=9.653157276e-01
alter vb dc=9.653157276e-01
option temp=-7.883797
op
let idx = 337
wrdata C:/Users/udhav/DVD-Project/work/pmos_off_0.out idx i(Vd) i(Vg) i(Vs) i(Vb) @m1[id] @m1[igs] @m1[igd] @m1[igcs] @m1[igcd] @m1[igb] @m1[igidl] @m1[igisl] @m1[isub] @m1[ibd] @m1[ibs]
destroy all
altermod pmos vth0=-4.378986849e-01
altermod pmos toxe=9.051415013e-10
altermod pmos ndep=5.279256850e+18
altermod pmos u0=5.601523362e-03
altermod pmos xj=4.804505913e-09
alter m1 w=4.123667094e-08
alter vd dc=7.107446728e-01
alter vg dc=9.264142632e-01
alter vs dc=9.358496838e-01
alter vb dc=9.532931419e-01
option temp=24.198757
op
let idx = 338
wrdata C:/Users/udhav/DVD-Project/work/pmos_off_0.out idx i(Vd) i(Vg) i(Vs) i(Vb) @m1[id] @m1[igs] @m1[igd] @m1[igcs] @m1[igcd] @m1[igb] @m1[igidl] @m1[igisl] @m1[isub] @m1[ibd] @m1[ibs]
destroy all
altermod pmos vth0=-4.606645364e-01
altermod pmos toxe=1.052419490e-09
altermod pmos ndep=5.009153836e+18
altermod pmos u0=6.152493572e-03
altermod pmos xj=5.181565456e-09
alter m1 w=1.143854979e-07
alter vd dc=0.000000000e+00
alter vg dc=1.003602227e+00
alter vs dc=1.001279639e-01
alter vb dc=1.003602227e+00
option temp=102.831832
op
let idx = 339
wrdata C:/Users/udhav/DVD-Project/work/pmos_off_0.out idx i(Vd) i(Vg) i(Vs) i(Vb) @m1[id] @m1[igs] @m1[igd] @m1[igcs] @m1[igcd] @m1[igb] @m1[igidl] @m1[igisl] @m1[isub] @m1[ibd] @m1[ibs]
destroy all
altermod pmos vth0=-4.103580856e-01
altermod pmos toxe=1.002371941e-09
altermod pmos ndep=5.618007138e+18
altermod pmos u0=5.722723366e-03
altermod pmos xj=4.782512907e-09
alter m1 w=1.106942324e-07
alter vd dc=1.044674352e-02
alter vg dc=1.004088382e+00
alter vs dc=0.000000000e+00
alter vb dc=1.004088382e+00
option temp=109.213562
op
let idx = 340
wrdata C:/Users/udhav/DVD-Project/work/pmos_off_0.out idx i(Vd) i(Vg) i(Vs) i(Vb) @m1[id] @m1[igs] @m1[igd] @m1[igcs] @m1[igcd] @m1[igb] @m1[igidl] @m1[igisl] @m1[isub] @m1[ibd] @m1[ibs]
destroy all
altermod pmos vth0=-4.528975444e-01
altermod pmos toxe=1.024769333e-09
altermod pmos ndep=5.025251058e+18
altermod pmos u0=5.612648464e-03
altermod pmos xj=5.356749110e-09
alter m1 w=5.846276014e-08
alter vd dc=3.112051290e-01
alter vg dc=1.078388425e+00
alter vs dc=1.611299494e-01
alter vb dc=1.078388425e+00
option temp=-26.949195
op
let idx = 341
wrdata C:/Users/udhav/DVD-Project/work/pmos_off_0.out idx i(Vd) i(Vg) i(Vs) i(Vb) @m1[id] @m1[igs] @m1[igd] @m1[igcs] @m1[igcd] @m1[igb] @m1[igidl] @m1[igisl] @m1[isub] @m1[ibd] @m1[ibs]
destroy all
altermod pmos vth0=-4.741410852e-01
altermod pmos toxe=9.818420537e-10
altermod pmos ndep=6.038616335e+18
altermod pmos u0=5.466655585e-03
altermod pmos xj=4.676104050e-09
alter m1 w=5.314573321e-08
alter vd dc=6.239526080e-01
alter vg dc=1.039269159e+00
alter vs dc=0.000000000e+00
alter vb dc=1.039269159e+00
option temp=77.933676
op
let idx = 342
wrdata C:/Users/udhav/DVD-Project/work/pmos_off_0.out idx i(Vd) i(Vg) i(Vs) i(Vb) @m1[id] @m1[igs] @m1[igd] @m1[igcs] @m1[igcd] @m1[igb] @m1[igidl] @m1[igisl] @m1[isub] @m1[ibd] @m1[ibs]
destroy all
altermod pmos vth0=-4.570180055e-01
altermod pmos toxe=1.057011670e-09
altermod pmos ndep=5.148101788e+18
altermod pmos u0=5.514256536e-03
altermod pmos xj=4.889812094e-09
alter m1 w=9.662829695e-08
alter vd dc=0.000000000e+00
alter vg dc=9.050365680e-01
alter vs dc=2.543538251e-01
alter vb dc=9.050365680e-01
option temp=77.651752
op
let idx = 343
wrdata C:/Users/udhav/DVD-Project/work/pmos_off_0.out idx i(Vd) i(Vg) i(Vs) i(Vb) @m1[id] @m1[igs] @m1[igd] @m1[igcs] @m1[igcd] @m1[igb] @m1[igidl] @m1[igisl] @m1[isub] @m1[ibd] @m1[ibs]
destroy all
altermod pmos vth0=-4.225689161e-01
altermod pmos toxe=1.030408966e-09
altermod pmos ndep=5.545836507e+18
altermod pmos u0=5.995518488e-03
altermod pmos xj=5.451464423e-09
alter m1 w=7.219893052e-08
alter vd dc=6.984673793e-01
alter vg dc=1.080764201e+00
alter vs dc=1.080764201e+00
alter vb dc=1.080764201e+00
option temp=-20.085558
op
let idx = 344
wrdata C:/Users/udhav/DVD-Project/work/pmos_off_0.out idx i(Vd) i(Vg) i(Vs) i(Vb) @m1[id] @m1[igs] @m1[igd] @m1[igcs] @m1[igcd] @m1[igb] @m1[igidl] @m1[igisl] @m1[isub] @m1[ibd] @m1[ibs]
destroy all
altermod pmos vth0=-4.440787159e-01
altermod pmos toxe=1.050180453e-09
altermod pmos ndep=5.570823250e+18
altermod pmos u0=6.163842103e-03
altermod pmos xj=4.636485479e-09
alter m1 w=8.646021099e-08
alter vd dc=9.173341747e-01
alter vg dc=8.523494688e-01
alter vs dc=0.000000000e+00
alter vb dc=9.173341747e-01
option temp=95.805599
op
let idx = 345
wrdata C:/Users/udhav/DVD-Project/work/pmos_off_0.out idx i(Vd) i(Vg) i(Vs) i(Vb) @m1[id] @m1[igs] @m1[igd] @m1[igcs] @m1[igcd] @m1[igb] @m1[igidl] @m1[igisl] @m1[isub] @m1[ibd] @m1[ibs]
destroy all
altermod pmos vth0=-4.448960228e-01
altermod pmos toxe=1.051618405e-09
altermod pmos ndep=5.759223162e+18
altermod pmos u0=6.556522203e-03
altermod pmos xj=4.843646967e-09
alter m1 w=8.049034094e-08
alter vd dc=9.948302456e-01
alter vg dc=1.010835958e+00
alter vs dc=0.000000000e+00
alter vb dc=1.010835958e+00
option temp=-9.164398
op
let idx = 346
wrdata C:/Users/udhav/DVD-Project/work/pmos_off_0.out idx i(Vd) i(Vg) i(Vs) i(Vb) @m1[id] @m1[igs] @m1[igd] @m1[igcs] @m1[igcd] @m1[igb] @m1[igidl] @m1[igisl] @m1[isub] @m1[ibd] @m1[ibs]
destroy all
altermod pmos vth0=-4.123643850e-01
altermod pmos toxe=9.014179058e-10
altermod pmos ndep=5.732565323e+18
altermod pmos u0=5.924810017e-03
altermod pmos xj=4.958093033e-09
alter m1 w=9.728589183e-08
alter vd dc=0.000000000e+00
alter vg dc=9.344550468e-01
alter vs dc=9.473932130e-01
alter vb dc=9.474057496e-01
option temp=1.705127
op
let idx = 347
wrdata C:/Users/udhav/DVD-Project/work/pmos_off_0.out idx i(Vd) i(Vg) i(Vs) i(Vb) @m1[id] @m1[igs] @m1[igd] @m1[igcs] @m1[igcd] @m1[igb] @m1[igidl] @m1[igisl] @m1[isub] @m1[ibd] @m1[ibs]
destroy all
altermod pmos vth0=-4.614633147e-01
altermod pmos toxe=9.840338278e-10
altermod pmos ndep=5.477867705e+18
altermod pmos u0=6.517271995e-03
altermod pmos xj=5.480017024e-09
alter m1 w=9.489709062e-08
alter vd dc=4.340990529e-01
alter vg dc=9.075655404e-01
alter vs dc=9.075655404e-01
alter vb dc=9.075655404e-01
option temp=-23.946699
op
let idx = 348
wrdata C:/Users/udhav/DVD-Project/work/pmos_off_0.out idx i(Vd) i(Vg) i(Vs) i(Vb) @m1[id] @m1[igs] @m1[igd] @m1[igcs] @m1[igcd] @m1[igb] @m1[igidl] @m1[igisl] @m1[isub] @m1[ibd] @m1[ibs]
destroy all
altermod pmos vth0=-4.471973799e-01
altermod pmos toxe=1.066940825e-09
altermod pmos ndep=5.665379300e+18
altermod pmos u0=6.362053201e-03
altermod pmos xj=5.165721835e-09
alter m1 w=7.670805370e-08
alter vd dc=9.651537889e-01
alter vg dc=9.965936463e-01
alter vs dc=0.000000000e+00
alter vb dc=9.965936463e-01
option temp=35.689808
op
let idx = 349
wrdata C:/Users/udhav/DVD-Project/work/pmos_off_0.out idx i(Vd) i(Vg) i(Vs) i(Vb) @m1[id] @m1[igs] @m1[igd] @m1[igcs] @m1[igcd] @m1[igb] @m1[igidl] @m1[igisl] @m1[isub] @m1[ibd] @m1[ibs]
destroy all
altermod pmos vth0=-4.265471281e-01
altermod pmos toxe=9.751915521e-10
altermod pmos ndep=5.815823799e+18
altermod pmos u0=5.621089374e-03
altermod pmos xj=4.998233467e-09
alter m1 w=9.907315399e-08
alter vd dc=0.000000000e+00
alter vg dc=9.934837648e-01
alter vs dc=1.033957314e+00
alter vb dc=1.033957314e+00
option temp=-36.144550
op
let idx = 350
wrdata C:/Users/udhav/DVD-Project/work/pmos_off_0.out idx i(Vd) i(Vg) i(Vs) i(Vb) @m1[id] @m1[igs] @m1[igd] @m1[igcs] @m1[igcd] @m1[igb] @m1[igidl] @m1[igisl] @m1[isub] @m1[ibd] @m1[ibs]
destroy all
altermod pmos vth0=-4.600107083e-01
altermod pmos toxe=9.417851924e-10
altermod pmos ndep=5.052004329e+18
altermod pmos u0=6.400335968e-03
altermod pmos xj=5.331987741e-09
alter m1 w=9.054852388e-08
alter vd dc=9.748795599e-01
alter vg dc=9.859146087e-01
alter vs dc=1.564013444e-01
alter vb dc=1.010179188e+00
option temp=96.229864
op
let idx = 351
wrdata C:/Users/udhav/DVD-Project/work/pmos_off_0.out idx i(Vd) i(Vg) i(Vs) i(Vb) @m1[id] @m1[igs] @m1[igd] @m1[igcs] @m1[igcd] @m1[igb] @m1[igidl] @m1[igisl] @m1[isub] @m1[ibd] @m1[ibs]
destroy all
altermod pmos vth0=-4.258091526e-01
altermod pmos toxe=9.513195487e-10
altermod pmos ndep=5.491918944e+18
altermod pmos u0=5.894236386e-03
altermod pmos xj=5.383893473e-09
alter m1 w=3.925792725e-08
alter vd dc=9.082607898e-01
alter vg dc=9.873859813e-01
alter vs dc=1.219529366e-01
alter vb dc=9.873859813e-01
option temp=-37.658383
op
let idx = 352
wrdata C:/Users/udhav/DVD-Project/work/pmos_off_0.out idx i(Vd) i(Vg) i(Vs) i(Vb) @m1[id] @m1[igs] @m1[igd] @m1[igcs] @m1[igcd] @m1[igb] @m1[igidl] @m1[igisl] @m1[isub] @m1[ibd] @m1[ibs]
destroy all
altermod pmos vth0=-4.023472332e-01
altermod pmos toxe=1.093215532e-09
altermod pmos ndep=5.687904842e+18
altermod pmos u0=6.005833712e-03
altermod pmos xj=5.457496629e-09
alter m1 w=4.760678821e-08
alter vd dc=3.410223215e-01
alter vg dc=9.047099709e-01
alter vs dc=2.625572098e-01
alter vb dc=9.562470293e-01
option temp=39.891944
op
let idx = 353
wrdata C:/Users/udhav/DVD-Project/work/pmos_off_0.out idx i(Vd) i(Vg) i(Vs) i(Vb) @m1[id] @m1[igs] @m1[igd] @m1[igcs] @m1[igcd] @m1[igb] @m1[igidl] @m1[igisl] @m1[isub] @m1[ibd] @m1[ibs]
destroy all
altermod pmos vth0=-4.371221172e-01
altermod pmos toxe=1.018433126e-09
altermod pmos ndep=5.488708791e+18
altermod pmos u0=6.493274085e-03
altermod pmos xj=4.754847805e-09
alter m1 w=7.887597098e-08
alter vd dc=2.634991377e-01
alter vg dc=1.012763368e+00
alter vs dc=8.820276167e-01
alter vb dc=1.051083777e+00
option temp=69.196698
op
let idx = 354
wrdata C:/Users/udhav/DVD-Project/work/pmos_off_0.out idx i(Vd) i(Vg) i(Vs) i(Vb) @m1[id] @m1[igs] @m1[igd] @m1[igcs] @m1[igcd] @m1[igb] @m1[igidl] @m1[igisl] @m1[isub] @m1[ibd] @m1[ibs]
destroy all
altermod pmos vth0=-4.023615763e-01
altermod pmos toxe=1.043152479e-09
altermod pmos ndep=5.993220185e+18
altermod pmos u0=6.097308787e-03
altermod pmos xj=5.398577605e-09
alter m1 w=6.475420770e-08
alter vd dc=1.037396795e-03
alter vg dc=9.861472136e-01
alter vs dc=5.371989824e-01
alter vb dc=1.003861726e+00
option temp=26.550207
op
let idx = 355
wrdata C:/Users/udhav/DVD-Project/work/pmos_off_0.out idx i(Vd) i(Vg) i(Vs) i(Vb) @m1[id] @m1[igs] @m1[igd] @m1[igcs] @m1[igcd] @m1[igb] @m1[igidl] @m1[igisl] @m1[isub] @m1[ibd] @m1[ibs]
destroy all
altermod pmos vth0=-4.436261149e-01
altermod pmos toxe=9.107988671e-10
altermod pmos ndep=4.986682388e+18
altermod pmos u0=5.770682622e-03
altermod pmos xj=5.344810238e-09
alter m1 w=1.129929181e-07
alter vd dc=4.084141574e-01
alter vg dc=1.021633438e+00
alter vs dc=0.000000000e+00
alter vb dc=1.021633438e+00
option temp=42.173220
op
let idx = 356
wrdata C:/Users/udhav/DVD-Project/work/pmos_off_0.out idx i(Vd) i(Vg) i(Vs) i(Vb) @m1[id] @m1[igs] @m1[igd] @m1[igcs] @m1[igcd] @m1[igb] @m1[igidl] @m1[igisl] @m1[isub] @m1[ibd] @m1[ibs]
destroy all
altermod pmos vth0=-3.907610874e-01
altermod pmos toxe=9.144141256e-10
altermod pmos ndep=5.423819390e+18
altermod pmos u0=5.428325536e-03
altermod pmos xj=4.744459481e-09
alter m1 w=6.584911111e-08
alter vd dc=1.076597888e+00
alter vg dc=1.076885080e+00
alter vs dc=1.076885080e+00
alter vb dc=1.076885080e+00
option temp=-27.425144
op
let idx = 357
wrdata C:/Users/udhav/DVD-Project/work/pmos_off_0.out idx i(Vd) i(Vg) i(Vs) i(Vb) @m1[id] @m1[igs] @m1[igd] @m1[igcs] @m1[igcd] @m1[igb] @m1[igidl] @m1[igisl] @m1[isub] @m1[ibd] @m1[ibs]
destroy all
altermod pmos vth0=-4.031923968e-01
altermod pmos toxe=9.451392255e-10
altermod pmos ndep=5.477015163e+18
altermod pmos u0=5.709867174e-03
altermod pmos xj=4.672866961e-09
alter m1 w=1.044355174e-07
alter vd dc=9.228790956e-01
alter vg dc=9.228790956e-01
alter vs dc=9.184552773e-01
alter vb dc=9.228790956e-01
option temp=27.044191
op
let idx = 358
wrdata C:/Users/udhav/DVD-Project/work/pmos_off_0.out idx i(Vd) i(Vg) i(Vs) i(Vb) @m1[id] @m1[igs] @m1[igd] @m1[igcs] @m1[igcd] @m1[igb] @m1[igidl] @m1[igisl] @m1[isub] @m1[ibd] @m1[ibs]
destroy all
altermod pmos vth0=-4.723099240e-01
altermod pmos toxe=1.005894611e-09
altermod pmos ndep=5.234486087e+18
altermod pmos u0=5.871471036e-03
altermod pmos xj=5.354145663e-09
alter m1 w=8.308323443e-08
alter vd dc=9.714348431e-01
alter vg dc=1.013575214e+00
alter vs dc=4.333032293e-01
alter vb dc=1.013575214e+00
option temp=88.745253
op
let idx = 359
wrdata C:/Users/udhav/DVD-Project/work/pmos_off_0.out idx i(Vd) i(Vg) i(Vs) i(Vb) @m1[id] @m1[igs] @m1[igd] @m1[igcs] @m1[igcd] @m1[igb] @m1[igidl] @m1[igisl] @m1[isub] @m1[ibd] @m1[ibs]
destroy all
altermod pmos vth0=-4.731676876e-01
altermod pmos toxe=9.267498254e-10
altermod pmos ndep=5.312082111e+18
altermod pmos u0=6.098934720e-03
altermod pmos xj=5.099026034e-09
alter m1 w=2.885062484e-08
alter vd dc=8.278908710e-01
alter vg dc=9.695209102e-01
alter vs dc=9.695209102e-01
alter vb dc=9.695209102e-01
option temp=35.974770
op
let idx = 360
wrdata C:/Users/udhav/DVD-Project/work/pmos_off_0.out idx i(Vd) i(Vg) i(Vs) i(Vb) @m1[id] @m1[igs] @m1[igd] @m1[igcs] @m1[igcd] @m1[igb] @m1[igidl] @m1[igisl] @m1[isub] @m1[ibd] @m1[ibs]
destroy all
altermod pmos vth0=-4.266868806e-01
altermod pmos toxe=1.022758257e-09
altermod pmos ndep=5.670133058e+18
altermod pmos u0=5.945483758e-03
altermod pmos xj=5.032341172e-09
alter m1 w=1.788881137e-08
alter vd dc=4.414533014e-01
alter vg dc=1.062523828e+00
alter vs dc=1.060841783e+00
alter vb dc=1.062523828e+00
option temp=103.448364
op
let idx = 361
wrdata C:/Users/udhav/DVD-Project/work/pmos_off_0.out idx i(Vd) i(Vg) i(Vs) i(Vb) @m1[id] @m1[igs] @m1[igd] @m1[igcs] @m1[igcd] @m1[igb] @m1[igidl] @m1[igisl] @m1[isub] @m1[ibd] @m1[ibs]
destroy all
altermod pmos vth0=-4.279051376e-01
altermod pmos toxe=1.063958704e-09
altermod pmos ndep=5.831768133e+18
altermod pmos u0=5.718401347e-03
altermod pmos xj=4.501987858e-09
alter m1 w=1.149153596e-07
alter vd dc=2.223817811e-01
alter vg dc=9.560664835e-01
alter vs dc=2.969947407e-01
alter vb dc=9.560664835e-01
option temp=-28.128241
op
let idx = 362
wrdata C:/Users/udhav/DVD-Project/work/pmos_off_0.out idx i(Vd) i(Vg) i(Vs) i(Vb) @m1[id] @m1[igs] @m1[igd] @m1[igcs] @m1[igcd] @m1[igb] @m1[igidl] @m1[igisl] @m1[isub] @m1[ibd] @m1[ibs]
destroy all
altermod pmos vth0=-3.920629679e-01
altermod pmos toxe=9.551487568e-10
altermod pmos ndep=5.002567460e+18
altermod pmos u0=6.364477896e-03
altermod pmos xj=5.429792219e-09
alter m1 w=5.664575056e-08
alter vd dc=9.433564011e-01
alter vg dc=1.063995210e+00
alter vs dc=6.282378027e-01
alter vb dc=1.089199795e+00
option temp=-37.045357
op
let idx = 363
wrdata C:/Users/udhav/DVD-Project/work/pmos_off_0.out idx i(Vd) i(Vg) i(Vs) i(Vb) @m1[id] @m1[igs] @m1[igd] @m1[igcs] @m1[igcd] @m1[igb] @m1[igidl] @m1[igisl] @m1[isub] @m1[ibd] @m1[ibs]
destroy all
altermod pmos vth0=-4.454492661e-01
altermod pmos toxe=1.001987413e-09
altermod pmos ndep=5.008086221e+18
altermod pmos u0=6.176236767e-03
altermod pmos xj=4.661494500e-09
alter m1 w=5.338690082e-08
alter vd dc=9.429572742e-01
alter vg dc=1.079013716e+00
alter vs dc=1.079013716e+00
alter vb dc=1.079013716e+00
option temp=8.563209
op
let idx = 364
wrdata C:/Users/udhav/DVD-Project/work/pmos_off_0.out idx i(Vd) i(Vg) i(Vs) i(Vb) @m1[id] @m1[igs] @m1[igd] @m1[igcs] @m1[igcd] @m1[igb] @m1[igidl] @m1[igisl] @m1[isub] @m1[ibd] @m1[ibs]
destroy all
altermod pmos vth0=-4.399451256e-01
altermod pmos toxe=9.846052938e-10
altermod pmos ndep=6.035838758e+18
altermod pmos u0=5.778758854e-03
altermod pmos xj=4.752379579e-09
alter m1 w=6.379130072e-08
alter vd dc=9.984425521e-01
alter vg dc=9.492865659e-01
alter vs dc=9.743554229e-01
alter vb dc=1.002364899e+00
option temp=56.085073
op
let idx = 365
wrdata C:/Users/udhav/DVD-Project/work/pmos_off_0.out idx i(Vd) i(Vg) i(Vs) i(Vb) @m1[id] @m1[igs] @m1[igd] @m1[igcs] @m1[igcd] @m1[igb] @m1[igidl] @m1[igisl] @m1[isub] @m1[ibd] @m1[ibs]
destroy all
altermod pmos vth0=-4.734975511e-01
altermod pmos toxe=1.091388519e-09
altermod pmos ndep=6.032379388e+18
altermod pmos u0=5.453520017e-03
altermod pmos xj=4.793059906e-09
alter m1 w=2.059150913e-08
alter vd dc=8.214857137e-03
alter vg dc=1.069406308e+00
alter vs dc=0.000000000e+00
alter vb dc=1.069406308e+00
option temp=-1.029417
op
let idx = 366
wrdata C:/Users/udhav/DVD-Project/work/pmos_off_0.out idx i(Vd) i(Vg) i(Vs) i(Vb) @m1[id] @m1[igs] @m1[igd] @m1[igcs] @m1[igcd] @m1[igb] @m1[igidl] @m1[igisl] @m1[isub] @m1[ibd] @m1[ibs]
destroy all
altermod pmos vth0=-4.162487963e-01
altermod pmos toxe=1.026398360e-09
altermod pmos ndep=5.352095055e+18
altermod pmos u0=5.790207453e-03
altermod pmos xj=5.224316345e-09
alter m1 w=5.851323957e-08
alter vd dc=0.000000000e+00
alter vg dc=1.006263526e+00
alter vs dc=0.000000000e+00
alter vb dc=1.006263526e+00
option temp=41.922717
op
let idx = 367
wrdata C:/Users/udhav/DVD-Project/work/pmos_off_0.out idx i(Vd) i(Vg) i(Vs) i(Vb) @m1[id] @m1[igs] @m1[igd] @m1[igcs] @m1[igcd] @m1[igb] @m1[igidl] @m1[igisl] @m1[isub] @m1[ibd] @m1[ibs]
destroy all
altermod pmos vth0=-4.058864667e-01
altermod pmos toxe=1.010932269e-09
altermod pmos ndep=5.549313179e+18
altermod pmos u0=6.471775435e-03
altermod pmos xj=4.897088872e-09
alter m1 w=1.931700937e-08
alter vd dc=1.010801534e+00
alter vg dc=9.430631585e-01
alter vs dc=4.394599003e-01
alter vb dc=1.044379378e+00
option temp=105.202175
op
let idx = 368
wrdata C:/Users/udhav/DVD-Project/work/pmos_off_0.out idx i(Vd) i(Vg) i(Vs) i(Vb) @m1[id] @m1[igs] @m1[igd] @m1[igcs] @m1[igcd] @m1[igb] @m1[igidl] @m1[igisl] @m1[isub] @m1[ibd] @m1[ibs]
destroy all
altermod pmos vth0=-4.104786687e-01
altermod pmos toxe=9.195638028e-10
altermod pmos ndep=5.757691545e+18
altermod pmos u0=6.148167443e-03
altermod pmos xj=4.835614049e-09
alter m1 w=2.147911381e-08
alter vd dc=9.577594133e-01
alter vg dc=8.903496577e-01
alter vs dc=0.000000000e+00
alter vb dc=9.577594133e-01
option temp=-26.753232
op
let idx = 369
wrdata C:/Users/udhav/DVD-Project/work/pmos_off_0.out idx i(Vd) i(Vg) i(Vs) i(Vb) @m1[id] @m1[igs] @m1[igd] @m1[igcs] @m1[igcd] @m1[igb] @m1[igidl] @m1[igisl] @m1[isub] @m1[ibd] @m1[ibs]
destroy all
altermod pmos vth0=-3.885131365e-01
altermod pmos toxe=9.933313006e-10
altermod pmos ndep=5.405990231e+18
altermod pmos u0=5.494168896e-03
altermod pmos xj=4.794227938e-09
alter m1 w=4.873333363e-08
alter vd dc=0.000000000e+00
alter vg dc=9.218795336e-01
alter vs dc=0.000000000e+00
alter vb dc=9.218795336e-01
option temp=66.134905
op
let idx = 370
wrdata C:/Users/udhav/DVD-Project/work/pmos_off_0.out idx i(Vd) i(Vg) i(Vs) i(Vb) @m1[id] @m1[igs] @m1[igd] @m1[igcs] @m1[igcd] @m1[igb] @m1[igidl] @m1[igisl] @m1[isub] @m1[ibd] @m1[ibs]
destroy all
altermod pmos vth0=-4.036582489e-01
altermod pmos toxe=1.080578106e-09
altermod pmos ndep=5.063956294e+18
altermod pmos u0=5.805052067e-03
altermod pmos xj=4.993091161e-09
alter m1 w=1.056994726e-07
alter vd dc=9.146425842e-01
alter vg dc=9.586863286e-01
alter vs dc=9.586863286e-01
alter vb dc=9.586863286e-01
option temp=1.500612
op
let idx = 371
wrdata C:/Users/udhav/DVD-Project/work/pmos_off_0.out idx i(Vd) i(Vg) i(Vs) i(Vb) @m1[id] @m1[igs] @m1[igd] @m1[igcs] @m1[igcd] @m1[igb] @m1[igidl] @m1[igisl] @m1[isub] @m1[ibd] @m1[ibs]
destroy all
altermod pmos vth0=-4.584494886e-01
altermod pmos toxe=9.647878456e-10
altermod pmos ndep=5.256085816e+18
altermod pmos u0=6.302705970e-03
altermod pmos xj=5.195713381e-09
alter m1 w=8.047871045e-08
alter vd dc=1.905459778e-03
alter vg dc=9.413752239e-01
alter vs dc=7.932154875e-01
alter vb dc=9.413752239e-01
option temp=91.498704
op
let idx = 372
wrdata C:/Users/udhav/DVD-Project/work/pmos_off_0.out idx i(Vd) i(Vg) i(Vs) i(Vb) @m1[id] @m1[igs] @m1[igd] @m1[igcs] @m1[igcd] @m1[igb] @m1[igidl] @m1[igisl] @m1[isub] @m1[ibd] @m1[ibs]
destroy all
altermod pmos vth0=-4.104987793e-01
altermod pmos toxe=1.084425315e-09
altermod pmos ndep=5.249944157e+18
altermod pmos u0=6.231172127e-03
altermod pmos xj=4.821262898e-09
alter m1 w=1.103776819e-07
alter vd dc=5.327739639e-01
alter vg dc=1.056055017e+00
alter vs dc=7.985809561e-02
alter vb dc=1.056055017e+00
option temp=17.286921
op
let idx = 373
wrdata C:/Users/udhav/DVD-Project/work/pmos_off_0.out idx i(Vd) i(Vg) i(Vs) i(Vb) @m1[id] @m1[igs] @m1[igd] @m1[igcs] @m1[igcd] @m1[igb] @m1[igidl] @m1[igisl] @m1[isub] @m1[ibd] @m1[ibs]
destroy all
altermod pmos vth0=-4.541112790e-01
altermod pmos toxe=1.009948211e-09
altermod pmos ndep=5.365847085e+18
altermod pmos u0=5.872372191e-03
altermod pmos xj=4.508817488e-09
alter m1 w=5.637626986e-08
alter vd dc=9.544273562e-01
alter vg dc=9.502072449e-01
alter vs dc=8.287842112e-01
alter vb dc=9.544273562e-01
option temp=24.558817
op
let idx = 374
wrdata C:/Users/udhav/DVD-Project/work/pmos_off_0.out idx i(Vd) i(Vg) i(Vs) i(Vb) @m1[id] @m1[igs] @m1[igd] @m1[igcs] @m1[igcd] @m1[igb] @m1[igidl] @m1[igisl] @m1[isub] @m1[ibd] @m1[ibs]
destroy all
altermod pmos vth0=-4.143393700e-01
altermod pmos toxe=1.000830177e-09
altermod pmos ndep=5.187523712e+18
altermod pmos u0=6.171723694e-03
altermod pmos xj=5.220884821e-09
alter m1 w=2.018411536e-08
alter vd dc=8.927801877e-02
alter vg dc=9.020420857e-01
alter vs dc=7.767187321e-01
alter vb dc=9.020420857e-01
option temp=49.672683
op
let idx = 375
wrdata C:/Users/udhav/DVD-Project/work/pmos_off_0.out idx i(Vd) i(Vg) i(Vs) i(Vb) @m1[id] @m1[igs] @m1[igd] @m1[igcs] @m1[igcd] @m1[igb] @m1[igidl] @m1[igisl] @m1[isub] @m1[ibd] @m1[ibs]
destroy all
altermod pmos vth0=-4.725387541e-01
altermod pmos toxe=9.328695699e-10
altermod pmos ndep=5.034065813e+18
altermod pmos u0=6.102386431e-03
altermod pmos xj=5.228179823e-09
alter m1 w=5.724298799e-08
alter vd dc=7.874693037e-01
alter vg dc=1.008917494e+00
alter vs dc=6.146426919e-03
alter vb dc=1.090055425e+00
option temp=98.467466
op
let idx = 376
wrdata C:/Users/udhav/DVD-Project/work/pmos_off_0.out idx i(Vd) i(Vg) i(Vs) i(Vb) @m1[id] @m1[igs] @m1[igd] @m1[igcs] @m1[igcd] @m1[igb] @m1[igidl] @m1[igisl] @m1[isub] @m1[ibd] @m1[ibs]
destroy all
altermod pmos vth0=-4.599893975e-01
altermod pmos toxe=9.498618922e-10
altermod pmos ndep=5.944800349e+18
altermod pmos u0=6.558712005e-03
altermod pmos xj=4.891601451e-09
alter m1 w=1.234993975e-07
alter vd dc=8.862968263e-01
alter vg dc=1.046690667e+00
alter vs dc=0.000000000e+00
alter vb dc=1.046690667e+00
option temp=1.421857
op
let idx = 377
wrdata C:/Users/udhav/DVD-Project/work/pmos_off_0.out idx i(Vd) i(Vg) i(Vs) i(Vb) @m1[id] @m1[igs] @m1[igd] @m1[igcs] @m1[igcd] @m1[igb] @m1[igidl] @m1[igisl] @m1[isub] @m1[ibd] @m1[ibs]
destroy all
altermod pmos vth0=-4.647966787e-01
altermod pmos toxe=9.532038853e-10
altermod pmos ndep=5.825471817e+18
altermod pmos u0=5.852610173e-03
altermod pmos xj=4.542750373e-09
alter m1 w=1.224784937e-07
alter vd dc=9.427711333e-01
alter vg dc=9.286474504e-01
alter vs dc=9.921632782e-01
alter vb dc=9.921776101e-01
option temp=10.085035
op
let idx = 378
wrdata C:/Users/udhav/DVD-Project/work/pmos_off_0.out idx i(Vd) i(Vg) i(Vs) i(Vb) @m1[id] @m1[igs] @m1[igd] @m1[igcs] @m1[igcd] @m1[igb] @m1[igidl] @m1[igisl] @m1[isub] @m1[ibd] @m1[ibs]
destroy all
altermod pmos vth0=-4.060563262e-01
altermod pmos toxe=1.064827247e-09
altermod pmos ndep=5.247620041e+18
altermod pmos u0=5.630999792e-03
altermod pmos xj=5.142885690e-09
alter m1 w=1.157298464e-07
alter vd dc=1.001448475e+00
alter vg dc=9.322398926e-01
alter vs dc=6.265866574e-02
alter vb dc=1.001448475e+00
option temp=-4.142905
op
let idx = 379
wrdata C:/Users/udhav/DVD-Project/work/pmos_off_0.out idx i(Vd) i(Vg) i(Vs) i(Vb) @m1[id] @m1[igs] @m1[igd] @m1[igcs] @m1[igcd] @m1[igb] @m1[igidl] @m1[igisl] @m1[isub] @m1[ibd] @m1[ibs]
destroy all
altermod pmos vth0=-4.674354147e-01
altermod pmos toxe=1.001374648e-09
altermod pmos ndep=5.504676674e+18
altermod pmos u0=6.573563437e-03
altermod pmos xj=5.174650672e-09
alter m1 w=1.267522767e-07
alter vd dc=5.452697119e-01
alter vg dc=9.455304797e-01
alter vs dc=5.693823139e-01
alter vb dc=9.455304797e-01
option temp=29.360984
op
let idx = 380
wrdata C:/Users/udhav/DVD-Project/work/pmos_off_0.out idx i(Vd) i(Vg) i(Vs) i(Vb) @m1[id] @m1[igs] @m1[igd] @m1[igcs] @m1[igcd] @m1[igb] @m1[igidl] @m1[igisl] @m1[isub] @m1[ibd] @m1[ibs]
destroy all
altermod pmos vth0=-4.126359140e-01
altermod pmos toxe=1.035664358e-09
altermod pmos ndep=4.952840742e+18
altermod pmos u0=6.286942388e-03
altermod pmos xj=4.903239906e-09
alter m1 w=1.181035918e-07
alter vd dc=8.998435075e-03
alter vg dc=1.067130582e+00
alter vs dc=1.067130582e+00
alter vb dc=1.067130582e+00
option temp=-33.352908
op
let idx = 381
wrdata C:/Users/udhav/DVD-Project/work/pmos_off_0.out idx i(Vd) i(Vg) i(Vs) i(Vb) @m1[id] @m1[igs] @m1[igd] @m1[igcs] @m1[igcd] @m1[igb] @m1[igidl] @m1[igisl] @m1[isub] @m1[ibd] @m1[ibs]
destroy all
altermod pmos vth0=-4.498163303e-01
altermod pmos toxe=1.099974558e-09
altermod pmos ndep=5.858222476e+18
altermod pmos u0=5.859693582e-03
altermod pmos xj=4.898252330e-09
alter m1 w=3.012329084e-08
alter vd dc=6.926723633e-01
alter vg dc=9.019197155e-01
alter vs dc=8.354781222e-02
alter vb dc=9.249167640e-01
option temp=105.840044
op
let idx = 382
wrdata C:/Users/udhav/DVD-Project/work/pmos_off_0.out idx i(Vd) i(Vg) i(Vs) i(Vb) @m1[id] @m1[igs] @m1[igd] @m1[igcs] @m1[igcd] @m1[igb] @m1[igidl] @m1[igisl] @m1[isub] @m1[ibd] @m1[ibs]
destroy all
altermod pmos vth0=-4.582931038e-01
altermod pmos toxe=1.067658224e-09
altermod pmos ndep=5.889516101e+18
altermod pmos u0=5.408500194e-03
altermod pmos xj=5.155955034e-09
alter m1 w=1.193012082e-07
alter vd dc=1.800869691e-01
alter vg dc=1.050835156e+00
alter vs dc=0.000000000e+00
alter vb dc=1.050835156e+00
option temp=80.531828
op
let idx = 383
wrdata C:/Users/udhav/DVD-Project/work/pmos_off_0.out idx i(Vd) i(Vg) i(Vs) i(Vb) @m1[id] @m1[igs] @m1[igd] @m1[igcs] @m1[igcd] @m1[igb] @m1[igidl] @m1[igisl] @m1[isub] @m1[ibd] @m1[ibs]
destroy all
altermod pmos vth0=-3.981796126e-01
altermod pmos toxe=9.723007816e-10
altermod pmos ndep=5.234509283e+18
altermod pmos u0=6.130051087e-03
altermod pmos xj=4.801346870e-09
alter m1 w=2.177818932e-08
alter vd dc=1.027009632e+00
alter vg dc=9.853817978e-01
alter vs dc=1.061033629e+00
alter vb dc=1.061033629e+00
option temp=43.145980
op
let idx = 384
wrdata C:/Users/udhav/DVD-Project/work/pmos_off_0.out idx i(Vd) i(Vg) i(Vs) i(Vb) @m1[id] @m1[igs] @m1[igd] @m1[igcs] @m1[igcd] @m1[igb] @m1[igidl] @m1[igisl] @m1[isub] @m1[ibd] @m1[ibs]
destroy all
altermod pmos vth0=-4.141604303e-01
altermod pmos toxe=1.059188703e-09
altermod pmos ndep=5.678193732e+18
altermod pmos u0=5.895750930e-03
altermod pmos xj=4.634727781e-09
alter m1 w=1.062983747e-07
alter vd dc=1.744586989e-01
alter vg dc=8.742166740e-01
alter vs dc=9.594077853e-01
alter vb dc=9.594077853e-01
option temp=31.989942
op
let idx = 385
wrdata C:/Users/udhav/DVD-Project/work/pmos_off_0.out idx i(Vd) i(Vg) i(Vs) i(Vb) @m1[id] @m1[igs] @m1[igd] @m1[igcs] @m1[igcd] @m1[igb] @m1[igidl] @m1[igisl] @m1[isub] @m1[ibd] @m1[ibs]
destroy all
altermod pmos vth0=-4.021494548e-01
altermod pmos toxe=1.033200065e-09
altermod pmos ndep=5.714133988e+18
altermod pmos u0=6.387702031e-03
altermod pmos xj=5.377440149e-09
alter m1 w=7.701407663e-08
alter vd dc=1.006807097e+00
alter vg dc=1.006807097e+00
alter vs dc=5.228467951e-03
alter vb dc=1.006807097e+00
option temp=55.771047
op
let idx = 386
wrdata C:/Users/udhav/DVD-Project/work/pmos_off_0.out idx i(Vd) i(Vg) i(Vs) i(Vb) @m1[id] @m1[igs] @m1[igd] @m1[igcs] @m1[igcd] @m1[igb] @m1[igidl] @m1[igisl] @m1[isub] @m1[ibd] @m1[ibs]
destroy all
altermod pmos vth0=-4.534780780e-01
altermod pmos toxe=9.565448165e-10
altermod pmos ndep=5.647226098e+18
altermod pmos u0=5.873101491e-03
altermod pmos xj=4.671122751e-09
alter m1 w=5.259534361e-08
alter vd dc=1.002434383e+00
alter vg dc=1.009888158e+00
alter vs dc=0.000000000e+00
alter vb dc=1.037249088e+00
option temp=-29.498856
op
let idx = 387
wrdata C:/Users/udhav/DVD-Project/work/pmos_off_0.out idx i(Vd) i(Vg) i(Vs) i(Vb) @m1[id] @m1[igs] @m1[igd] @m1[igcs] @m1[igcd] @m1[igb] @m1[igidl] @m1[igisl] @m1[isub] @m1[ibd] @m1[ibs]
destroy all
altermod pmos vth0=-4.383937735e-01
altermod pmos toxe=1.022114656e-09
altermod pmos ndep=5.426990416e+18
altermod pmos u0=6.215572912e-03
altermod pmos xj=5.249264792e-09
alter m1 w=1.165386790e-07
alter vd dc=1.044594790e+00
alter vg dc=1.044594790e+00
alter vs dc=0.000000000e+00
alter vb dc=1.044594790e+00
option temp=74.443776
op
let idx = 388
wrdata C:/Users/udhav/DVD-Project/work/pmos_off_0.out idx i(Vd) i(Vg) i(Vs) i(Vb) @m1[id] @m1[igs] @m1[igd] @m1[igcs] @m1[igcd] @m1[igb] @m1[igidl] @m1[igisl] @m1[isub] @m1[ibd] @m1[ibs]
destroy all
altermod pmos vth0=-4.674583784e-01
altermod pmos toxe=9.097160867e-10
altermod pmos ndep=5.230559243e+18
altermod pmos u0=5.897777306e-03
altermod pmos xj=4.703346205e-09
alter m1 w=4.474634400e-08
alter vd dc=8.054674010e-01
alter vg dc=8.592769408e-01
alter vs dc=6.186205663e-02
alter vb dc=9.337963913e-01
option temp=59.811377
op
let idx = 389
wrdata C:/Users/udhav/DVD-Project/work/pmos_off_0.out idx i(Vd) i(Vg) i(Vs) i(Vb) @m1[id] @m1[igs] @m1[igd] @m1[igcs] @m1[igcd] @m1[igb] @m1[igidl] @m1[igisl] @m1[isub] @m1[ibd] @m1[ibs]
destroy all
altermod pmos vth0=-4.024798878e-01
altermod pmos toxe=9.992397946e-10
altermod pmos ndep=5.170492636e+18
altermod pmos u0=5.741653343e-03
altermod pmos xj=4.866591632e-09
alter m1 w=9.194319742e-08
alter vd dc=0.000000000e+00
alter vg dc=1.090269587e+00
alter vs dc=0.000000000e+00
alter vb dc=1.090269587e+00
option temp=91.012571
op
let idx = 390
wrdata C:/Users/udhav/DVD-Project/work/pmos_off_0.out idx i(Vd) i(Vg) i(Vs) i(Vb) @m1[id] @m1[igs] @m1[igd] @m1[igcs] @m1[igcd] @m1[igb] @m1[igidl] @m1[igisl] @m1[isub] @m1[ibd] @m1[ibs]
destroy all
altermod pmos vth0=-4.627193004e-01
altermod pmos toxe=9.337506454e-10
altermod pmos ndep=5.852705767e+18
altermod pmos u0=5.418194388e-03
altermod pmos xj=5.069869300e-09
alter m1 w=2.622114644e-08
alter vd dc=4.251360159e-01
alter vg dc=1.032932902e+00
alter vs dc=1.255269287e-01
alter vb dc=1.032932902e+00
option temp=44.530449
op
let idx = 391
wrdata C:/Users/udhav/DVD-Project/work/pmos_off_0.out idx i(Vd) i(Vg) i(Vs) i(Vb) @m1[id] @m1[igs] @m1[igd] @m1[igcs] @m1[igcd] @m1[igb] @m1[igidl] @m1[igisl] @m1[isub] @m1[ibd] @m1[ibs]
destroy all
altermod pmos vth0=-4.201925375e-01
altermod pmos toxe=1.099826545e-09
altermod pmos ndep=5.147562419e+18
altermod pmos u0=5.889140180e-03
altermod pmos xj=5.234995140e-09
alter m1 w=1.108110491e-07
alter vd dc=1.195164532e-01
alter vg dc=9.846989248e-01
alter vs dc=2.203893624e-01
alter vb dc=9.846989248e-01
option temp=76.753183
op
let idx = 392
wrdata C:/Users/udhav/DVD-Project/work/pmos_off_0.out idx i(Vd) i(Vg) i(Vs) i(Vb) @m1[id] @m1[igs] @m1[igd] @m1[igcs] @m1[igcd] @m1[igb] @m1[igidl] @m1[igisl] @m1[isub] @m1[ibd] @m1[ibs]
destroy all
altermod pmos vth0=-4.017782547e-01
altermod pmos toxe=9.059819822e-10
altermod pmos ndep=5.826158830e+18
altermod pmos u0=6.250901540e-03
altermod pmos xj=5.028592042e-09
alter m1 w=7.764942750e-08
alter vd dc=6.290497137e-01
alter vg dc=9.141913253e-01
alter vs dc=9.971416577e-01
alter vb dc=9.971416577e-01
option temp=38.626670
op
let idx = 393
wrdata C:/Users/udhav/DVD-Project/work/pmos_off_0.out idx i(Vd) i(Vg) i(Vs) i(Vb) @m1[id] @m1[igs] @m1[igd] @m1[igcs] @m1[igcd] @m1[igb] @m1[igidl] @m1[igisl] @m1[isub] @m1[ibd] @m1[ibs]
destroy all
altermod pmos vth0=-4.154542788e-01
altermod pmos toxe=1.023588616e-09
altermod pmos ndep=5.638074623e+18
altermod pmos u0=6.418465147e-03
altermod pmos xj=4.690033832e-09
alter m1 w=7.425953143e-08
alter vd dc=8.486573419e-01
alter vg dc=1.026574333e+00
alter vs dc=0.000000000e+00
alter vb dc=1.050221513e+00
option temp=-33.966706
op
let idx = 394
wrdata C:/Users/udhav/DVD-Project/work/pmos_off_0.out idx i(Vd) i(Vg) i(Vs) i(Vb) @m1[id] @m1[igs] @m1[igd] @m1[igcs] @m1[igcd] @m1[igb] @m1[igidl] @m1[igisl] @m1[isub] @m1[ibd] @m1[ibs]
destroy all
altermod pmos vth0=-4.410723777e-01
altermod pmos toxe=9.768260383e-10
altermod pmos ndep=5.404885167e+18
altermod pmos u0=5.553460625e-03
altermod pmos xj=5.048932893e-09
alter m1 w=9.354827878e-08
alter vd dc=7.019497106e-01
alter vg dc=1.018162040e+00
alter vs dc=5.825778014e-01
alter vb dc=1.082922074e+00
option temp=105.475785
op
let idx = 395
wrdata C:/Users/udhav/DVD-Project/work/pmos_off_0.out idx i(Vd) i(Vg) i(Vs) i(Vb) @m1[id] @m1[igs] @m1[igd] @m1[igcs] @m1[igcd] @m1[igb] @m1[igidl] @m1[igisl] @m1[isub] @m1[ibd] @m1[ibs]
destroy all
altermod pmos vth0=-4.359671776e-01
altermod pmos toxe=1.015988508e-09
altermod pmos ndep=5.473624975e+18
altermod pmos u0=5.977288893e-03
altermod pmos xj=5.368522956e-09
alter m1 w=8.338397199e-08
alter vd dc=0.000000000e+00
alter vg dc=9.055190966e-01
alter vs dc=2.098407772e-01
alter vb dc=9.055190966e-01
option temp=-10.057951
op
let idx = 396
wrdata C:/Users/udhav/DVD-Project/work/pmos_off_0.out idx i(Vd) i(Vg) i(Vs) i(Vb) @m1[id] @m1[igs] @m1[igd] @m1[igcs] @m1[igcd] @m1[igb] @m1[igidl] @m1[igisl] @m1[isub] @m1[ibd] @m1[ibs]
destroy all
altermod pmos vth0=-4.571417966e-01
altermod pmos toxe=1.038540581e-09
altermod pmos ndep=5.778222670e+18
altermod pmos u0=6.530443033e-03
altermod pmos xj=5.412819236e-09
alter m1 w=7.189846718e-08
alter vd dc=8.831137806e-01
alter vg dc=9.107669410e-01
alter vs dc=2.231378256e-01
alter vb dc=9.107669410e-01
option temp=115.358171
op
let idx = 397
wrdata C:/Users/udhav/DVD-Project/work/pmos_off_0.out idx i(Vd) i(Vg) i(Vs) i(Vb) @m1[id] @m1[igs] @m1[igd] @m1[igcs] @m1[igcd] @m1[igb] @m1[igidl] @m1[igisl] @m1[isub] @m1[ibd] @m1[ibs]
destroy all
altermod pmos vth0=-4.122050939e-01
altermod pmos toxe=1.002061407e-09
altermod pmos ndep=5.218813166e+18
altermod pmos u0=5.977786093e-03
altermod pmos xj=4.635360000e-09
alter m1 w=2.573806789e-08
alter vd dc=0.000000000e+00
alter vg dc=1.096964990e+00
alter vs dc=1.096964990e+00
alter vb dc=1.096964990e+00
option temp=112.587522
op
let idx = 398
wrdata C:/Users/udhav/DVD-Project/work/pmos_off_0.out idx i(Vd) i(Vg) i(Vs) i(Vb) @m1[id] @m1[igs] @m1[igd] @m1[igcs] @m1[igcd] @m1[igb] @m1[igidl] @m1[igisl] @m1[isub] @m1[ibd] @m1[ibs]
destroy all
altermod pmos vth0=-3.921539613e-01
altermod pmos toxe=9.618728638e-10
altermod pmos ndep=5.475714664e+18
altermod pmos u0=5.773442323e-03
altermod pmos xj=5.148915869e-09
alter m1 w=8.899730366e-08
alter vd dc=1.414785010e-03
alter vg dc=1.063430827e+00
alter vs dc=9.450852165e-02
alter vb dc=1.063430827e+00
option temp=3.725871
op
let idx = 399
wrdata C:/Users/udhav/DVD-Project/work/pmos_off_0.out idx i(Vd) i(Vg) i(Vs) i(Vb) @m1[id] @m1[igs] @m1[igd] @m1[igcs] @m1[igcd] @m1[igb] @m1[igidl] @m1[igisl] @m1[isub] @m1[ibd] @m1[ibs]
destroy all
altermod pmos vth0=-3.917052478e-01
altermod pmos toxe=9.119618798e-10
altermod pmos ndep=5.350002482e+18
altermod pmos u0=5.468371892e-03
altermod pmos xj=5.037566301e-09
alter m1 w=5.200622616e-08
alter vd dc=8.938980863e-01
alter vg dc=9.834723869e-01
alter vs dc=3.664235572e-01
alter vb dc=1.048713315e+00
option temp=-31.719128
op
let idx = 400
wrdata C:/Users/udhav/DVD-Project/work/pmos_off_0.out idx i(Vd) i(Vg) i(Vs) i(Vb) @m1[id] @m1[igs] @m1[igd] @m1[igcs] @m1[igcd] @m1[igb] @m1[igidl] @m1[igisl] @m1[isub] @m1[ibd] @m1[ibs]
destroy all
altermod pmos vth0=-4.206633101e-01
altermod pmos toxe=9.191117090e-10
altermod pmos ndep=5.562385851e+18
altermod pmos u0=6.337817729e-03
altermod pmos xj=5.182695185e-09
alter m1 w=6.105468257e-08
alter vd dc=8.883975821e-01
alter vg dc=1.070665764e+00
alter vs dc=1.080037040e+00
alter vb dc=1.080037040e+00
option temp=-28.610508
op
let idx = 401
wrdata C:/Users/udhav/DVD-Project/work/pmos_off_0.out idx i(Vd) i(Vg) i(Vs) i(Vb) @m1[id] @m1[igs] @m1[igd] @m1[igcs] @m1[igcd] @m1[igb] @m1[igidl] @m1[igisl] @m1[isub] @m1[ibd] @m1[ibs]
destroy all
altermod pmos vth0=-4.665817411e-01
altermod pmos toxe=1.001007129e-09
altermod pmos ndep=5.949762303e+18
altermod pmos u0=5.837831401e-03
altermod pmos xj=5.447377352e-09
alter m1 w=6.098550691e-08
alter vd dc=9.707475955e-02
alter vg dc=9.559227964e-01
alter vs dc=1.026354586e+00
alter vb dc=1.050207671e+00
option temp=13.962376
op
let idx = 402
wrdata C:/Users/udhav/DVD-Project/work/pmos_off_0.out idx i(Vd) i(Vg) i(Vs) i(Vb) @m1[id] @m1[igs] @m1[igd] @m1[igcs] @m1[igcd] @m1[igb] @m1[igidl] @m1[igisl] @m1[isub] @m1[ibd] @m1[ibs]
destroy all
altermod pmos vth0=-4.634895070e-01
altermod pmos toxe=9.239125673e-10
altermod pmos ndep=4.989321456e+18
altermod pmos u0=5.661543270e-03
altermod pmos xj=4.908140361e-09
alter m1 w=5.428218985e-08
alter vd dc=1.726744457e-02
alter vg dc=1.023877636e+00
alter vs dc=3.290983126e-01
alter vb dc=1.042610887e+00
option temp=-32.750472
op
let idx = 403
wrdata C:/Users/udhav/DVD-Project/work/pmos_off_0.out idx i(Vd) i(Vg) i(Vs) i(Vb) @m1[id] @m1[igs] @m1[igd] @m1[igcs] @m1[igcd] @m1[igb] @m1[igidl] @m1[igisl] @m1[isub] @m1[ibd] @m1[ibs]
destroy all
altermod pmos vth0=-4.077128072e-01
altermod pmos toxe=1.096240880e-09
altermod pmos ndep=4.996369494e+18
altermod pmos u0=5.705979032e-03
altermod pmos xj=5.172165479e-09
alter m1 w=5.539010006e-08
alter vd dc=8.516802113e-01
alter vg dc=1.029955627e+00
alter vs dc=0.000000000e+00
alter vb dc=1.029955627e+00
option temp=109.968465
op
let idx = 404
wrdata C:/Users/udhav/DVD-Project/work/pmos_off_0.out idx i(Vd) i(Vg) i(Vs) i(Vb) @m1[id] @m1[igs] @m1[igd] @m1[igcs] @m1[igcd] @m1[igb] @m1[igidl] @m1[igisl] @m1[isub] @m1[ibd] @m1[ibs]
destroy all
altermod pmos vth0=-4.330923281e-01
altermod pmos toxe=9.032698851e-10
altermod pmos ndep=5.367501605e+18
altermod pmos u0=5.747874915e-03
altermod pmos xj=5.483470227e-09
alter m1 w=5.452559729e-08
alter vd dc=2.883421674e-01
alter vg dc=1.054269374e+00
alter vs dc=7.986988935e-03
alter vb dc=1.054269374e+00
option temp=97.772500
op
let idx = 405
wrdata C:/Users/udhav/DVD-Project/work/pmos_off_0.out idx i(Vd) i(Vg) i(Vs) i(Vb) @m1[id] @m1[igs] @m1[igd] @m1[igcs] @m1[igcd] @m1[igb] @m1[igidl] @m1[igisl] @m1[isub] @m1[ibd] @m1[ibs]
destroy all
altermod pmos vth0=-4.358509634e-01
altermod pmos toxe=9.377135920e-10
altermod pmos ndep=5.809128981e+18
altermod pmos u0=5.807575666e-03
altermod pmos xj=5.233940233e-09
alter m1 w=8.152999675e-08
alter vd dc=3.786624872e-01
alter vg dc=9.927248905e-01
alter vs dc=9.927248905e-01
alter vb dc=9.927248905e-01
option temp=124.326828
op
let idx = 406
wrdata C:/Users/udhav/DVD-Project/work/pmos_off_0.out idx i(Vd) i(Vg) i(Vs) i(Vb) @m1[id] @m1[igs] @m1[igd] @m1[igcs] @m1[igcd] @m1[igb] @m1[igidl] @m1[igisl] @m1[isub] @m1[ibd] @m1[ibs]
destroy all
altermod pmos vth0=-4.727409764e-01
altermod pmos toxe=1.058629328e-09
altermod pmos ndep=5.789212930e+18
altermod pmos u0=6.471591536e-03
altermod pmos xj=5.161196295e-09
alter m1 w=1.263194719e-07
alter vd dc=9.689954260e-01
alter vg dc=9.898428417e-01
alter vs dc=8.060000933e-01
alter vb dc=9.898428417e-01
option temp=31.223155
op
let idx = 407
wrdata C:/Users/udhav/DVD-Project/work/pmos_off_0.out idx i(Vd) i(Vg) i(Vs) i(Vb) @m1[id] @m1[igs] @m1[igd] @m1[igcs] @m1[igcd] @m1[igb] @m1[igidl] @m1[igisl] @m1[isub] @m1[ibd] @m1[ibs]
destroy all
altermod pmos vth0=-4.235926379e-01
altermod pmos toxe=1.001904679e-09
altermod pmos ndep=5.288423150e+18
altermod pmos u0=5.762730555e-03
altermod pmos xj=5.276065816e-09
alter m1 w=9.644858962e-08
alter vd dc=7.998282679e-01
alter vg dc=9.138303998e-01
alter vs dc=7.843633977e-02
alter vb dc=9.706280884e-01
option temp=-23.165755
op
let idx = 408
wrdata C:/Users/udhav/DVD-Project/work/pmos_off_0.out idx i(Vd) i(Vg) i(Vs) i(Vb) @m1[id] @m1[igs] @m1[igd] @m1[igcs] @m1[igcd] @m1[igb] @m1[igidl] @m1[igisl] @m1[isub] @m1[ibd] @m1[ibs]
destroy all
altermod pmos vth0=-4.532578352e-01
altermod pmos toxe=1.070452215e-09
altermod pmos ndep=5.120103066e+18
altermod pmos u0=6.425005261e-03
altermod pmos xj=4.892884938e-09
alter m1 w=3.250107747e-08
alter vd dc=7.676687891e-01
alter vg dc=9.835451283e-01
alter vs dc=9.464084649e-01
alter vb dc=1.017167477e+00
option temp=-1.371941
op
let idx = 409
wrdata C:/Users/udhav/DVD-Project/work/pmos_off_0.out idx i(Vd) i(Vg) i(Vs) i(Vb) @m1[id] @m1[igs] @m1[igd] @m1[igcs] @m1[igcd] @m1[igb] @m1[igidl] @m1[igisl] @m1[isub] @m1[ibd] @m1[ibs]
destroy all
altermod pmos vth0=-3.966146987e-01
altermod pmos toxe=1.086499954e-09
altermod pmos ndep=5.959649446e+18
altermod pmos u0=6.597290853e-03
altermod pmos xj=4.783899778e-09
alter m1 w=1.045376715e-07
alter vd dc=6.353427513e-01
alter vg dc=9.697466060e-01
alter vs dc=0.000000000e+00
alter vb dc=9.697466060e-01
option temp=83.293122
op
let idx = 410
wrdata C:/Users/udhav/DVD-Project/work/pmos_off_0.out idx i(Vd) i(Vg) i(Vs) i(Vb) @m1[id] @m1[igs] @m1[igd] @m1[igcs] @m1[igcd] @m1[igb] @m1[igidl] @m1[igisl] @m1[isub] @m1[ibd] @m1[ibs]
destroy all
altermod pmos vth0=-4.601733259e-01
altermod pmos toxe=1.098417348e-09
altermod pmos ndep=5.585765053e+18
altermod pmos u0=5.569702061e-03
altermod pmos xj=4.811594425e-09
alter m1 w=9.675150577e-08
alter vd dc=9.745644947e-01
alter vg dc=8.870468935e-01
alter vs dc=0.000000000e+00
alter vb dc=9.745644947e-01
option temp=119.310441
op
let idx = 411
wrdata C:/Users/udhav/DVD-Project/work/pmos_off_0.out idx i(Vd) i(Vg) i(Vs) i(Vb) @m1[id] @m1[igs] @m1[igd] @m1[igcs] @m1[igcd] @m1[igb] @m1[igidl] @m1[igisl] @m1[isub] @m1[ibd] @m1[ibs]
destroy all
altermod pmos vth0=-3.944168103e-01
altermod pmos toxe=9.777474902e-10
altermod pmos ndep=5.482079414e+18
altermod pmos u0=6.570639498e-03
altermod pmos xj=4.926048750e-09
alter m1 w=1.279354151e-07
alter vd dc=6.190360792e-03
alter vg dc=1.019599161e+00
alter vs dc=4.141533964e-01
alter vb dc=1.019599161e+00
option temp=10.773933
op
let idx = 412
wrdata C:/Users/udhav/DVD-Project/work/pmos_off_0.out idx i(Vd) i(Vg) i(Vs) i(Vb) @m1[id] @m1[igs] @m1[igd] @m1[igcs] @m1[igcd] @m1[igb] @m1[igidl] @m1[igisl] @m1[isub] @m1[ibd] @m1[ibs]
destroy all
altermod pmos vth0=-4.211444164e-01
altermod pmos toxe=1.035786968e-09
altermod pmos ndep=5.600425331e+18
altermod pmos u0=5.825125811e-03
altermod pmos xj=5.466524379e-09
alter m1 w=1.056784634e-07
alter vd dc=6.580626728e-01
alter vg dc=1.033893950e+00
alter vs dc=9.596633459e-01
alter vb dc=1.033893950e+00
option temp=65.710760
op
let idx = 413
wrdata C:/Users/udhav/DVD-Project/work/pmos_off_0.out idx i(Vd) i(Vg) i(Vs) i(Vb) @m1[id] @m1[igs] @m1[igd] @m1[igcs] @m1[igcd] @m1[igb] @m1[igidl] @m1[igisl] @m1[isub] @m1[ibd] @m1[ibs]
destroy all
altermod pmos vth0=-4.367251421e-01
altermod pmos toxe=9.879045038e-10
altermod pmos ndep=5.593519889e+18
altermod pmos u0=6.584851241e-03
altermod pmos xj=4.977232031e-09
alter m1 w=3.260805954e-08
alter vd dc=2.334107488e-01
alter vg dc=9.034520380e-01
alter vs dc=1.630305025e-01
alter vb dc=9.507830837e-01
option temp=19.809239
op
let idx = 414
wrdata C:/Users/udhav/DVD-Project/work/pmos_off_0.out idx i(Vd) i(Vg) i(Vs) i(Vb) @m1[id] @m1[igs] @m1[igd] @m1[igcs] @m1[igcd] @m1[igb] @m1[igidl] @m1[igisl] @m1[isub] @m1[ibd] @m1[ibs]
destroy all
altermod pmos vth0=-4.530995604e-01
altermod pmos toxe=1.007866648e-09
altermod pmos ndep=5.882831987e+18
altermod pmos u0=5.978588125e-03
altermod pmos xj=5.134353090e-09
alter m1 w=1.051597985e-07
alter vd dc=9.636711882e-01
alter vg dc=9.972652761e-01
alter vs dc=0.000000000e+00
alter vb dc=1.086540807e+00
option temp=103.192163
op
let idx = 415
wrdata C:/Users/udhav/DVD-Project/work/pmos_off_0.out idx i(Vd) i(Vg) i(Vs) i(Vb) @m1[id] @m1[igs] @m1[igd] @m1[igcs] @m1[igcd] @m1[igb] @m1[igidl] @m1[igisl] @m1[isub] @m1[ibd] @m1[ibs]
destroy all
altermod pmos vth0=-4.024131486e-01
altermod pmos toxe=9.435537749e-10
altermod pmos ndep=5.577064035e+18
altermod pmos u0=6.192705859e-03
altermod pmos xj=4.579907776e-09
alter m1 w=5.221088767e-08
alter vd dc=5.803450867e-02
alter vg dc=1.044042835e+00
alter vs dc=0.000000000e+00
alter vb dc=1.044042835e+00
option temp=0.504469
op
let idx = 416
wrdata C:/Users/udhav/DVD-Project/work/pmos_off_0.out idx i(Vd) i(Vg) i(Vs) i(Vb) @m1[id] @m1[igs] @m1[igd] @m1[igcs] @m1[igcd] @m1[igb] @m1[igidl] @m1[igisl] @m1[isub] @m1[ibd] @m1[ibs]
destroy all
.endc
.end
